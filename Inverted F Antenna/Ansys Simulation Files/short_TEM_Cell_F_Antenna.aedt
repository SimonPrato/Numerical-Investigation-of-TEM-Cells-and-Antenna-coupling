# Ansys Electronics Desktop project, version 2024.2
materials:
  vacuum: permittivity=1

design HFSSDesign1 (HFSS, HFSS Terminal Network, model units mm)
geometry:
  Box1 [vacuum] = box(corner=(0mm, 0mm, 0mm), size=(300mm, 200mm, 100mm))
  Polyline1 = polyline((0mm, 0mm, 50mm) (0mm, 200mm, 50mm))
  coordinate_system RelativeCS1 = origin=(0mm, 0mm, 50mm) x=(1mm, 0mm, 0mm) y=(0mm, 1mm, 0mm)
  Polyline2 [vacuum] = polyline((0mm, 35mm, 0mm) (0mm, 165mm, 0mm)) in RelativeCS1
  Polyline2.sweep_along_vector((300mm, 0mm, 0mm)) in RelativeCS1
  Polyline2.sweep_along_vector((0mm, 0mm, 1mm)) in RelativeCS1
  Polyline2.move(0mm, 0mm, -0.5mm) in RelativeCS1
  [Polyline2, Box1].scale(0.5, 1, 1) in RelativeCS1
  Rectangle3 = rectangle(corner=(75mm, 35mm, 0.5mm), y_size=130mm, z_size=49.5mm) in RelativeCS1
  Rectangle4 = rectangle(corner=(0mm, 200mm, -50mm), y_size=-200mm, z_size=100mm) in RelativeCS1
  Rectangle5 = rectangle(corner=(150mm, 200mm, -50mm), y_size=-200mm, z_size=100mm) in RelativeCS1
  coordinate_system RelativeCS3 = origin=(75mm, 165mm, 50mm) x=(1mm, 0mm, 0mm) y=(0mm, 1mm, 0mm) in RelativeCS1
  coordinate_system RelativeCS4 = origin=(0mm, -65mm, 0mm) x=(1mm, 0mm, 0mm) y=(0mm, 1mm, 0mm) in RelativeCS3
  short1 = component(short, 3D_Component_File_Path="C:/Users/Simon Prato/Documents/Persoenliches/Studium/Masterarbeit/Inverted F Antenna/Ansys Simulation Files/inverted_f_antenna_short_signal_conductor.a3dcomp")
  0_8 [copper] = part_of(short1) in RelativeCS4
  Box1_1 [FR4_epoxy] = part_of(short1) in RelativeCS4
  Rectangle1 [vacuum] = part_of(short1) in RelativeCS4
  short1.rotate(RotateAxis=Z RotateAngle=90deg) in RelativeCS4
  short1.rotate(RotateAxis=Y RotateAngle=270deg) in RelativeCS4
  short1.move(TranslateVectorX=0.1mm TranslateVectorY=0.00210849mm TranslateVectorZ=-0.101508mm) in RelativeCS4
  short1.rotate(RotateAxis=Z RotateAngle=270deg) in RelativeCS4
boundaries and excitations:
  PerfE1: Perfect E Objects=Box1
  1: Wave Port Objects=Rectangle4 WavePortType=Modal NumModes=1 Modes{Mode1{IntLine{(0, 165, 50.5) -> (0, 35, 100)} CharImp=Zpi}}
  2: Wave Port Objects=Rectangle5 WavePortType=Modal NumModes=1 Modes{Mode1{IntLine{(150, 165, 50.5) -> (150, 35, 100)} CharImp=Zpi}}
  short1_1: Lumped Port Objects=Rectangle1 LumpedPortType=Modal Modes{Mode1{IntLine{(75.00210849, 99.85, 99.898492) -> (75.45889449, 99.85, 99.898492)} CharImp=Zpi RenormImp=50ohm}} Impedance=50ohm
setups:
  Setup1: HfssDrivenAuto AutoSolverSetting=Balanced Type=Interpolating
    sweep Sweep: 0GHz to 1GHz, 501 points;
source amplitudes:
  1:1: 1V 0deg
  2:1, short1_1:1: 0V 0deg
field plots:
  Vector_E1, Mag_E1: E Field over Rectangle3.face on Setup1 : LastAdaptive at Freq=0.55GHz Phase=0deg
reports:
  Terminal S Parameter Plot 1: dB(St(short1_1,1)) vs Freq on Setup1 : Sweep
  S Parameter Plot 1: dB(S(short1_1,1)), dB(S(short1_1,2)) vs Freq on Setup1 : Sweep
