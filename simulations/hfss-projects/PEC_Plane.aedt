# Ansys Electronics Desktop project, version 2025.1
materials:
  pec: conductivity=1e+30
  perfect conductor: conductivity=1e+30
  vacuum: permittivity=1

design current_loop (HFSS, HFSS Modal Network, model units mm)
variables:
  b = 12mm  # 17
  w = 30mm/2  # 27/2
  a = 400mm  # 20
  length = 800mm  # 100
  t = 0.1mm  # 0.1
  antenna_width = 1.6mm
  current_loop_radius = 0.101mm
  antenna_wire_radius = 0.1mm
  feedpoint_height = 1.6mm
  antenna_rotation_angle = 0deg
  antenna_offset = 0mm
  pos_loop1 = 1
  pos_loop2 = 1
  pos_loop3 = 8
geometry:
  upper_cell_wall = rectangle(corner=(-length/2, -a, b), x_size=length, y_size=2*a)
  RadiatingSurface [vacuum] = region(absolute_offset: +X=0mm, -X=0mm, +Y=10mm, -Y=10mm, +Z=10mm, -Z=10mm)
  coordinate_system RelativeCS9 = origin=(-75mm, 100mm, -100mm) x=(1mm, 0mm, 0mm) y=(0mm, 1mm, 0mm)
  coordinate_system RelativeCS10 = origin=(0mm, 0mm, -60mm) x=(1mm, 0mm, 0mm) y=(0mm, 1mm, 0mm) in RelativeCS9
  coordinate_system RelativeCS11 = origin=(235mm, 130mm, 0mm) x=(1mm, 0mm, 0mm) y=(0mm, 1mm, 0mm) in RelativeCS10
  coordinate_system RelativeCS12 = origin=(-85mm, -165mm, 110.5mm) x=(1mm, 0mm, 0mm) y=(0mm, 1mm, 0mm) in RelativeCS11
  coordinate_system RelativeCS13 = origin=(-75mm, -65mm, 49.5mm) x=(1mm, 0mm, 0mm) y=(0mm, 1mm, 0mm) in RelativeCS12
  coordinate_system RelativeCS14 = origin=(235mm, 130mm, 0mm) x=(1mm, 0mm, 0mm) y=(0mm, 1mm, 0mm) in RelativeCS13
  coordinate_system RelativeCS15 = origin=(-85mm, -165mm, 110.5mm) x=(1mm, 0mm, 0mm) y=(0mm, 1mm, 0mm) in RelativeCS14
  coordinate_system RelativeCS16 = origin=(1mm, 0.14142136mm, 10.35mm) x=(1mm, 0mm, 0mm) y=(0mm, 1mm, 0mm)
  coordinate_system RelativeCS17 = origin=(-0.1mm, 0mm, 1.65mm) x=(1mm, 0mm, 0mm) y=(0mm, 1mm, 0mm) in RelativeCS16
  coordinate_system RelativeCS18 = origin=(0.1mm, 0mm, 0mm) x=(1mm, 0mm, 0mm) y=(0mm, 1mm, 0mm) in RelativeCS17
  coordinate_system RelativeCS38 = origin=(-14.8mm, 3.2mm, 0mm) x=(1mm, 0mm, 0mm) y=(0mm, 1mm, 0mm) in RelativeCS37
  coordinate_system RelativeCS39 = origin=(-58.2mm, 26.541421mm, 0.05mm) x=(1mm, 0mm, 0mm) y=(0mm, 1mm, 0mm) in RelativeCS38
  coordinate_system RelativeCS40 = origin=(61.4mm, -27.8mm, 0mm) x=(1mm, 0mm, 0mm) y=(0mm, 1mm, 0mm) in RelativeCS39
  coordinate_system RelativeCS41 = origin=(-61.4mm, 27.8mm, -0.05mm) x=(1mm, 0mm, 0mm) y=(0mm, 1mm, 0mm) in RelativeCS40
  coordinate_system RelativeCS42 = origin=(4mm, 0mm, 0mm) x=(1mm, 0mm, 0mm) y=(0mm, 1mm, 0mm) in RelativeCS41
  coordinate_system RelativeCS43 = origin=(-4mm, 0mm, 0mm) x=(1mm, 0mm, 0mm) y=(0mm, 1mm, 0mm) in RelativeCS42
  coordinate_system RelativeCS44 = origin=((-0.70000000000001+0.7) mm, -0.005mm, 0mm) x=(1mm, 0mm, 0mm) y=(0mm, 1mm, 0mm) in RelativeCS43
  Cylinder6 = cylinder(axis=Z, base_centre=(0mm, antenna_offset, 0mm), radius=0.23mm, height=0.1mm) in RelativeCS44
  upper_cell_wall.subtract(Cylinder6)
  antenna_port = circle(normal=Z, centre=(0mm, 0mm, 0mm), radius=0.23mm) in RelativeCS44
  Circle3 = circle(normal=Z, centre=(0mm, 0mm, -1.55mm), radius=0.1mm) in RelativeCS18
  antenna_port.subtract(Circle3)
  Circle4 = circle(normal=Z, centre=(0mm, 0mm, 0mm), radius=0.1mm) in RelativeCS18
  antenna_port.subtract(Circle4)
  antenna_port_cap [pec] = object_from(antenna_port.edge(1 of 1))
  antenna_port_cap.thicken(0.05mm)
  coordinate_system RelativeCS19 = origin=(1.1mm, 0mm, -1.5mm) x=(1mm, 0mm, 0mm) y=(0mm, 1mm, 0mm) in RelativeCS18
  coordinate_system RelativeCS20 = origin=(-1.1mm, 0mm, 1.55mm) x=(1mm, 0mm, 0mm) y=(0mm, 1mm, 0mm) in RelativeCS19
  coordinate_system RelativeCS21 = origin=(-50mm, 0mm, 12mm) x=(1mm, 0mm, 0mm) y=(0mm, 1mm, 0mm)
  point Point1 = (0mm, 0mm, -6mm) in RelativeCS21
  coordinate_system RelativeCS22 = origin=(50mm, 0mm, -12mm) x=(1mm, 0mm, 0mm) y=(0mm, 1mm, 0mm) in RelativeCS21
  coordinate_system RelativeCS31 = origin=(-75mm, 100mm, -100mm) x=(1mm, 0mm, 0mm) y=(0mm, 1mm, 0mm) in RelativeCS22
  coordinate_system RelativeCS32 = origin=(0mm, 0mm, -60mm) x=(1mm, 0mm, 0mm) y=(0mm, 1mm, 0mm) in RelativeCS31
  coordinate_system RelativeCS23 = origin=(235mm, 130mm, 0mm) x=(1mm, 0mm, 0mm) y=(0mm, 1mm, 0mm) in RelativeCS32
  coordinate_system RelativeCS24 = origin=(-85mm, -165mm, 110.5mm) x=(1mm, 0mm, 0mm) y=(0mm, 1mm, 0mm) in RelativeCS23
  coordinate_system RelativeCS25 = origin=(-75mm, -65mm, 49.5mm) x=(1mm, 0mm, 0mm) y=(0mm, 1mm, 0mm) in RelativeCS24
  coordinate_system RelativeCS26 = origin=(235mm, 130mm, 0mm) x=(1mm, 0mm, 0mm) y=(0mm, 1mm, 0mm) in RelativeCS25
  coordinate_system RelativeCS27 = origin=(-85mm, -165mm, 110.5mm) x=(1mm, 0mm, 0mm) y=(0mm, 1mm, 0mm) in RelativeCS26
  coordinate_system RelativeCS28 = origin=(1mm, 0.14142136mm, 10.35mm) x=(1mm, 0mm, 0mm) y=(0mm, 1mm, 0mm) in RelativeCS22
  coordinate_system RelativeCS29 = origin=(-0.1mm, 0mm, 1.65mm) x=(1mm, 0mm, 0mm) y=(0mm, 1mm, 0mm) in RelativeCS28
  coordinate_system RelativeCS30 = origin=(0.1mm, 0mm, 0mm) x=(1mm, 0mm, 0mm) y=(0mm, 1mm, 0mm) in RelativeCS29
  coordinate_system RelativeCS33 = origin=(50mm, 0mm, -0.05005mm) x=(1mm, 0mm, 0mm) y=(0mm, 1mm, 0mm) in RelativeCS22
  coordinate_system RelativeCS34 = origin=(0mm, 0mm, 0.05mm) x=(1mm, 0mm, 0mm) y=(0mm, 1mm, 0mm) in RelativeCS33
  point Point2 = (0mm, 0mm, 6mm) in RelativeCS34
  coordinate_system RelativeCS35 = origin=(-49mm, 0.14142136mm, 12.00005mm) x=(1mm, 0mm, 0mm) y=(0mm, 1mm, 0mm) in RelativeCS34
  coordinate_system RelativeCS36 = origin=(-1mm, -0.14142136mm, 0mm) x=(1mm, 0mm, 0mm) y=(0mm, 1mm, 0mm) in RelativeCS35
  coordinate_system RelativeCS37 = origin=(73mm, -29.6mm, 0mm) x=(1mm, 0mm, 0mm) y=(0mm, 1mm, 0mm) in RelativeCS36
  Antenna [perfect conductor] = cylinder(axis=Z, base_centre=(0mm, 0mm, 0mm), radius=antenna_wire_radius, height=-feedpoint_height) in RelativeCS44
  Cylinder8 = cylinder(axis=X, base_centre=(-antenna_wire_radius, 0mm, -feedpoint_height), radius=antenna_wire_radius, height=antenna_width) in RelativeCS44
  Cylinder9 = cylinder(axis=Z, base_centre=(antenna_width-antenna_wire_radius, 0mm, -feedpoint_height-antenna_wire_radius), radius=antenna_wire_radius, height=feedpoint_height+antenna_wire_radius) in RelativeCS44
  Antenna.unite(Cylinder8, Cylinder9)
  current_loop_1 = circle(normal=Z, centre=(0mm, 0mm, (-feedpoint_height+antenna_wire_radius)/9*pos_loop1), radius=current_loop_radius) in RelativeCS44
  current_loop_2 = circle(normal=X, centre=(antenna_wire_radius + (antenna_width-3*antenna_wire_radius)/9 *pos_loop2, 0mm, -feedpoint_height), radius=current_loop_radius) in RelativeCS44
  current_loop_3 = circle(normal=Z, centre=(antenna_width-antenna_wire_radius, 0mm, -feedpoint_height+antenna_wire_radius+(feedpoint_height-antenna_wire_radius)/9*pos_loop3), radius=current_loop_radius) in RelativeCS44
  [Antenna, current_loop_1, current_loop_2, current_loop_3].rotate(axis=Z, angle=antenna_rotation_angle) in RelativeCS44
  [Antenna, antenna_port, antenna_port_cap, current_loop_1, current_loop_2, current_loop_3].move(0mm, antenna_offset, 0mm) in RelativeCS44
  voltage_line_1 = polyline((0.23mm, 0mm, 0mm) (0.101mm, 0mm, -0.16666667mm)) in RelativeCS44
boundaries and excitations:
  PerfE1: Perfect E Objects=upper_cell_wall
  Open1: Radiation Objects=RadiatingSurface
  antenna: Wave Port Objects=antenna_port WavePortType=Modal NumModes=1 Modes{Mode1{CharImp=Zpi}}
setups:
  Setup1: HfssDriven Frequency=3GHz MaxDeltaS=0.0002 MaximumPasses=30 MinimumPasses=1 MinimumConvergedPasses=1 PercentRefinement=30 BasisOrder=1 PortAccuracy=2 DrivenSolverType="Direct Solver"
    sweep Sweep: 1MHz to 3GHz, 30 points; Type=Discrete SaveFields
source amplitudes:
  antenna:1: 1W 0deg
field calculator expressions:
  curr_loop_1_real = <Hx,Hy,Hz> | Real | Tangent | Dot | EnterLine(current_loop_1) | LineValue | Integrate
  curr_loop_1_imag = <Hx,Hy,Hz> | Imag | Tangent | Dot | EnterLine(current_loop_1) | LineValue | Integrate
  antenna_power = Poynting | Real | Normal | Dot | EnterSurface(antenna_port) | SurfaceValue | Integrate
  output_ez = Fundamental_Quantity(0) | EnterPoint(Point1) | PointValue | CmplxMag | ScalarZ
  voltage_line_1_real = Fundamental_Quantity(0) | Real | Tangent | Dot | EnterLine(voltage_line_1) | LineValue | Integrate
  voltage_line_1_imag = Fundamental_Quantity(0) | Imag | Tangent | Dot | EnterLine(voltage_line_1) | LineValue | Integrate
  curr_loop2_real = <Hx,Hy,Hz> | Real | Tangent | Dot | EnterLine(current_loop_2) | LineValue | Integrate
  curr_loop2_imag = <Hx,Hy,Hz> | Imag | Tangent | Dot | EnterLine(current_loop_2) | LineValue | Integrate
  curr_loop3_real = <Hx,Hy,Hz> | Real | Tangent | Dot | EnterLine(current_loop_3) | LineValue | Integrate
  curr_loop3_imag = <Hx,Hy,Hz> | Imag | Tangent | Dot | EnterLine(current_loop_3) | LineValue | Integrate
  elec_energy = Fundamental_Quantity(0) | Fundamental_Quantity(0) | Conj | Dot | Real | EnterVolume(RadiatingSurface) | VolumeValue | Integrate
  mag_energy = <Hx,Hy,Hz> | <Hx,Hy,Hz> | Conj | Dot | Real | EnterVolume(RadiatingSurface) | VolumeValue | Integrate
reports:
  Feed Current: sqrt((1-mag(S(antenna,antenna))**2)/cos(atan(im(S(antenna,antenna))/(1+re(S(antenna,antenna))))-atan((-im(S(antenna,antenna))/(1-re(S(antenna,antenna))))))/(re(Zo(antenna))*(sqrt((1+re(S(antenna,antenna)))**2+im(S(antenna,antenna))**2))/(sqrt((1-re(S(antenna,antenna)))**2+im(S(antenna,antenna))**2))))*sqrt(2) vs Freq on Setup1 : Sweep [Phase=0deg]
  feed Voltage: sqrt(re(Zo(antenna))*(sqrt((1+re(S(antenna,antenna)))**2+im(S(antenna,antenna))**2))/(sqrt((1-re(S(antenna,antenna)))**2+im(S(antenna,antenna))**2))*(1-mag(S(antenna,antenna))**2)/cos(atan(im(S(antenna,antenna))/(1+re(S(antenna,antenna))))-atan((-im(S(antenna,antenna))/(1-re(S(antenna,antenna))))))) vs Freq on Setup1 : Sweep [Phase=0deg]
  Return Path Current: sqrt(curr_loop3_real*curr_loop3_real+curr_loop3_imag*curr_loop3_imag) vs Freq on Setup1 : Sweep [Phase=0deg]
  Feed Current vs Return Path Current: sqrt(curr_loop3_real*curr_loop3_real+curr_loop3_imag*curr_loop3_imag), sqrt(curr_loop_1_real*curr_loop_1_real+curr_loop_1_imag*curr_loop_1_imag) vs Freq on Setup1 : Sweep [Phase=0deg]
  Electric Energy: elec_energy*0.5*8.8541878128e-12 vs Freq on Setup1 : Sweep [Phase=0deg]
  Magnetic Energy: mag_energy*0.5*1.256637e-6 vs Freq on Setup1 : Sweep [Phase=0deg]
  Capacitance: elec_energy*8.8541878128e-12/(sqrt(re(Zo(antenna))*(sqrt((1+re(S(antenna,antenna)))**2+im(S(antenna,antenna))**2))/(sqrt((1-re(S(antenna,antenna)))**2+im(S(antenna,antenna))**2))*(1-mag(S(antenna,antenna))**2)/cos(atan(im(S(antenna,antenna))/(1+re(S(antenna,antenna))))-atan((-im(S(antenna,antenna))/(1-re(S(antenna,antenna)))))))*sqrt(2))**2 vs Freq on Setup1 : Sweep [Phase=0deg]; markers MX1 at x=1.0011236e+09
  Inductance: mag_energy*1.256637e-6/(sqrt((1-mag(S(antenna,antenna))**2)/cos(atan(im(S(antenna,antenna))/(1+re(S(antenna,antenna))))-atan((-im(S(antenna,antenna))/(1-re(S(antenna,antenna))))))/(re(Zo(antenna))*(sqrt((1+re(S(antenna,antenna)))**2+im(S(antenna,antenna))**2))/(sqrt((1-re(S(antenna,antenna)))**2+im(S(antenna,antenna))**2))))*sqrt(2))**2 vs Freq on Setup1 : Sweep [Phase=0deg]; markers MX1 at x=1e+09
