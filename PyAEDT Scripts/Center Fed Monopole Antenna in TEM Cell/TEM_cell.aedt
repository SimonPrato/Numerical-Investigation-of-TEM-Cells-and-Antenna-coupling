# Ansys Electronics Desktop project, version 2024.2
materials:
  vacuum: permittivity=1
  copper: permeability=0.999991 conductivity=58000000

design HFSSDesign1 (HFSS, HFSS Terminal Network, model units mm)
geometry:
  short_TEM_cell_model1 = component(short_TEM_cell_model, 3D_Component_File_Path="C:/Users/Simon Prato/Documents/Persoenliches/Studium/Masterarbeit/TEM Cell/Ansys Simulation Files/short_TEM_cell_model.a3dcomp")
  Box1, Polyline1, Polyline2, Rectangle3, Rectangle4, Rectangle5, Polyline3 [vacuum] = part_of(short_TEM_cell_model1)
  coordinate_system RelativeCS8 = origin=(8.1906568mm, 0.2mm, 0.04546245mm) x=(1mm, 0mm, 0mm) y=(0mm, 1mm, 0mm)
  Rectangle6 = rectangle(corner=(1.8mm, 0mm, -0.05mm), z_size=0.05mm, x_size=0.2mm) in RelativeCS8
  Rectangle6.move(-1.8mm, 0mm, 0mm) in RelativeCS8
  Rectangle6.move(1.8mm, 0mm, 0mm) in RelativeCS8
  Rectangle6.move(-1.8mm, 0mm, 0mm) in RelativeCS8
  Rectangle6.move(1.8mm, 0mm, 0mm) in RelativeCS8
  Rectangle6.move(-1.8mm, 0mm, 0mm) in RelativeCS8
boundaries and excitations:
  short_TEM_cell_model1_PerfE1: Perfect E Objects=Box1
  Rectangle6_T1: Terminal port=1 Edges=Rectangle6.edge(at (8.29066, 0.2, -0.00453755)) TerminalResistance=50ohm
  short_TEM_cell_model1_1: Wave Port Objects=Rectangle4 WavePortType=Modal NumModes=1 Modes{Mode1{IntLine{(-66.809343, 65.2, -49.45453755) -> (-66.809343, -64.8, 0.04546245)} CharImp=Zpi}}
  short_TEM_cell_model1_2: Wave Port Objects=Rectangle5 WavePortType=Modal NumModes=1 Modes{Mode1{IntLine{(83.190657, 65.2, -49.45453755) -> (83.190657, -64.8, 0.04546245)} CharImp=Zpi}}
  1: Lumped Port Faces=Rectangle6.face(at (8.29066, 0.2, 0.0204624)) LumpedPortType=Terminal Impedance=50ohm
  reference conductors: Box1
setups:
  Setup1: HfssDrivenAuto AutoSolverSetting=Balanced Type=Interpolating
    sweep Sweep: 0GHz to 1GHz, 501 points;
source amplitudes:
  short_TEM_cell_model1_1:1: 1V 0deg
  short_TEM_cell_model1_2:1, 1:1: 0V 0deg
