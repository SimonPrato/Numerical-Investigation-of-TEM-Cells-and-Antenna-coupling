# Ansys Electronics Desktop project, version 2024.1
project variables:
  $GndPinXxX = 1mm
  $GndPadXxX = 6mm
  $GndPinLength = 1mm
  $PinLength = 1mm
  $AntPadStep = 0.1mm
  $Diameter1 = 1.3mm
  $AntiPadDiameter = 4mm
  $GndPadHigth = 1mm
  $Diameter2 = 4.35mm
  $ConnectorHight = 4.5mm
  $Diameter3 = 5mm
  $freq = 0MHz
materials:
  copper: permeability=0.999991 conductivity=58000000
  vacuum: permittivity=1
  FR4_epoxy: permittivity=4.4 permeability=1 dielectric_loss_tangent=0.02
  Teflon (tm): permittivity=2.1 dielectric_loss_tangent=0.001
  gold: permeability=0.99996 conductivity=41000000
  pec: conductivity=1e+30

design Antenna (HFSS, HFSS Modal Network, model units mm)
variables:
  b = 12mm  # 17
  w = 30mm/2  # 27/2
  a = 20mm  # 20
  length = 100mm  # 100
  t = 0.1mm  # 0.1
  Y0 = 0mm
  Z0 = b/2
  alphaXY = 0deg
  alphaXZ = 0deg
  yOffset = 0mm
  zOffset = 0mm
geometry:
  Rectangle1 = rectangle(corner=(-length/2, -a, b), x_size=length, y_size=2*a)
  Rectangle1_1 = Rectangle1.duplicate_around_axis(axis=X, angle=180deg, total=2)
  Rectangle2 = rectangle(corner=(-length/2, -a, -b), z_size=2*b, x_size=length)
  Rectangle2_1 = Rectangle2.duplicate_around_axis(axis=X, angle=180deg, total=2)
  Rectangle3 [copper, solve inside] = rectangle(corner=(-length/2, -w, (-t/2) mm), x_size=length, y_size=2*w)
  Rectangle3.thicken(t, both sides)
  Rectangle4 = rectangle(corner=(-length/2, -a, -b), y_size=2*a, z_size=2*b)
  Rectangle4_1 = Rectangle4.duplicate_around_axis(axis=Z, angle=180deg, total=2)
  Box1 [vacuum] = box(corner=(-length/2, -a, -b), size=(length, 2*a, 2*b))
  RadiatingSurface [vacuum] = region(absolute_offset: +X=0mm, -X=0mm, +Y=10mm, -Y=10mm, +Z=10mm, -Z=10mm)
  FieldProbe = Rectangle1.duplicate_along_line(step=(0mm, 0mm, -b/2), total=2)
  coordinate_system RelativeCS9 = origin=(-75mm, 100mm, -100mm) x=(1mm, 0mm, 0mm) y=(0mm, 1mm, 0mm)
  coordinate_system RelativeCS10 = origin=(0mm, 0mm, -60mm) x=(1mm, 0mm, 0mm) y=(0mm, 1mm, 0mm) in RelativeCS9
  coordinate_system RelativeCS11 = origin=(235mm, 130mm, 0mm) x=(1mm, 0mm, 0mm) y=(0mm, 1mm, 0mm) in RelativeCS10
  coordinate_system RelativeCS12 = origin=(-85mm, -165mm, 110.5mm) x=(1mm, 0mm, 0mm) y=(0mm, 1mm, 0mm) in RelativeCS11
  coordinate_system RelativeCS13 = origin=(-75mm, -65mm, 49.5mm) x=(1mm, 0mm, 0mm) y=(0mm, 1mm, 0mm) in RelativeCS12
  coordinate_system RelativeCS14 = origin=(235mm, 130mm, 0mm) x=(1mm, 0mm, 0mm) y=(0mm, 1mm, 0mm) in RelativeCS13
  coordinate_system RelativeCS15 = origin=(-85mm, -165mm, 110.5mm) x=(1mm, 0mm, 0mm) y=(0mm, 1mm, 0mm) in RelativeCS14
  coordinate_system RelativeCS16 = origin=(1mm, 0.14142136mm, 10.35mm) x=(1mm, 0mm, 0mm) y=(0mm, 1mm, 0mm)
  coordinate_system RelativeCS17 = origin=(-0.1mm, 0mm, 1.65mm) x=(1mm, 0mm, 0mm) y=(0mm, 1mm, 0mm) in RelativeCS16
  coordinate_system RelativeCS18 = origin=(0.1mm, 0mm, 0mm) x=(1mm, 0mm, 0mm) y=(0mm, 1mm, 0mm) in RelativeCS17
  Circle1 = circle(normal=Z, centre=(0mm, 0mm, -1.55mm), radius=0.2mm) in RelativeCS18
  Rectangle1.subtract(Circle1)
  Cylinder6 = cylinder(axis=Z, base_centre=(0mm, 0mm, 0mm), radius=0.2mm, height=0.1mm) in RelativeCS18
  Rectangle1.subtract(Cylinder6)
  Circle2 = circle(normal=Z, centre=(0mm, 0mm, 0mm), radius=0.2mm) in RelativeCS18
  Circle3 = circle(normal=Z, centre=(0mm, 0mm, -1.55mm), radius=0.1mm) in RelativeCS18
  Circle2.subtract(Circle3)
  Circle4 = circle(normal=Z, centre=(0mm, 0mm, 0mm), radius=0.1mm) in RelativeCS18
  Circle2.subtract(Circle4)
  pecCap1 [pec] = object_from(Circle2.edge(at (0.8, 0.141421, 12)))
  pecCap1.thicken(0.05mm)
  Rectangle5 = rectangle(corner=(-1mm, 19.858579mm, 0mm), y_size=-40mm, z_size=-24mm) in RelativeCS18
  coordinate_system RelativeCS19 = origin=(1.1mm, 0mm, -1.5mm) x=(1mm, 0mm, 0mm) y=(0mm, 1mm, 0mm) in RelativeCS18
  coordinate_system RelativeCS20 = origin=(-1.1mm, 0mm, 1.55mm) x=(1mm, 0mm, 0mm) y=(0mm, 1mm, 0mm) in RelativeCS19
  coordinate_system RelativeCS21 = origin=(-50mm, 0mm, 12mm) x=(1mm, 0mm, 0mm) y=(0mm, 1mm, 0mm)
  point Point1 = (0mm, 0mm, -6mm) in RelativeCS21
  coordinate_system RelativeCS22 = origin=(50mm, 0mm, -12mm) x=(1mm, 0mm, 0mm) y=(0mm, 1mm, 0mm) in RelativeCS21
  coordinate_system RelativeCS31 = origin=(-75mm, 100mm, -100mm) x=(1mm, 0mm, 0mm) y=(0mm, 1mm, 0mm) in RelativeCS22
  coordinate_system RelativeCS32 = origin=(0mm, 0mm, -60mm) x=(1mm, 0mm, 0mm) y=(0mm, 1mm, 0mm) in RelativeCS31
  coordinate_system RelativeCS23 = origin=(235mm, 130mm, 0mm) x=(1mm, 0mm, 0mm) y=(0mm, 1mm, 0mm) in RelativeCS32
  coordinate_system RelativeCS24 = origin=(-85mm, -165mm, 110.5mm) x=(1mm, 0mm, 0mm) y=(0mm, 1mm, 0mm) in RelativeCS23
  coordinate_system RelativeCS25 = origin=(-75mm, -65mm, 49.5mm) x=(1mm, 0mm, 0mm) y=(0mm, 1mm, 0mm) in RelativeCS24
  Antenna [copper] = cylinder(axis=Z, base_centre=(1mm, 0mm, -0.05mm), radius=0.1mm, height=0.05mm) in RelativeCS25
  Antenna.move(0mm, 0mm, 0mm) in RelativeCS22
  Antenna.move(0mm, 0mm, 5mm) in RelativeCS22
  Antenna.move(0mm, 0.14142136mm, 7mm) in RelativeCS22
  coordinate_system RelativeCS26 = origin=(235mm, 130mm, 0mm) x=(1mm, 0mm, 0mm) y=(0mm, 1mm, 0mm) in RelativeCS25
  coordinate_system RelativeCS27 = origin=(-85mm, -165mm, 110.5mm) x=(1mm, 0mm, 0mm) y=(0mm, 1mm, 0mm) in RelativeCS26
  Cylinder4 = cylinder(axis=Z, base_centre=(75mm, -165.1mm, 159.95mm), radius=0.1mm, height=0.05mm) in RelativeCS25
  Cylinder4.move(0.041421356mm, 65.1mm, 0mm) in RelativeCS25
  Cylinder4.move(-0.041421356mm, -0.24142136mm, 0mm) in RelativeCS25
  Cylinder4.move(1.2414214mm, 0.24142136mm, 2.8421709e-14mm) in RelativeCS27
  Cylinder4.move(-1.2414214mm, 0mm, 0mm) in RelativeCS27
  Cylinder4.move(-75.1mm, 100mm, -160.05mm) in RelativeCS25
  Cylinder4.move(0.1mm, 0mm, 0.05mm) in RelativeCS25
  Cylinder4.move(0mm, 0mm, 0mm) in RelativeCS22
  Cylinder4.move(0mm, 0mm, 5mm) in RelativeCS22
  Cylinder4.move(0mm, 0.14142136mm, 7mm) in RelativeCS22
  Cylinder1 = cylinder(axis=Z, base_centre=(0mm, 0mm, 0mm), radius=0.1mm, height=-5mm) in RelativeCS22
  Cylinder2 = cylinder(axis=Z, base_centre=(1mm, 0mm, 0mm), radius=0.1mm, height=-1.5mm) in RelativeCS22
  Cylinder3 = cylinder(axis=X, base_centre=(1mm, 0mm, -1.5mm), radius=0.1mm, height=-1mm) in RelativeCS22
  Cylinder1.unite(Cylinder2, Cylinder3)
  Cylinder1.move(-75mm, -100mm, -100mm) in RelativeCS22
  Cylinder1.move(0mm, -109.5mm, 247mm) in RelativeCS32
  Cylinder1.move(75mm, 144.5mm, -147mm) in RelativeCS32
  Cylinder1.move(1.4210855e-14mm, 0mm, -0.05mm) in RelativeCS32
  Cylinder1.move(0mm, 65mm, 2.8421709e-14mm) in RelativeCS32
  Cylinder1.move(0mm, 0mm, 0mm) in RelativeCS22
  Cylinder1.move(0mm, 0mm, 0mm) in RelativeCS22
  Cylinder1.move(0mm, 0mm, 5mm) in RelativeCS22
  Cylinder1.move(0mm, 0.14142136mm, 7mm) in RelativeCS22
  Cylinder4.unite(Cylinder1)
  Antenna.unite(Cylinder4)
  coordinate_system RelativeCS28 = origin=(1mm, 0.14142136mm, 10.35mm) x=(1mm, 0mm, 0mm) y=(0mm, 1mm, 0mm) in RelativeCS22
  coordinate_system RelativeCS29 = origin=(-0.1mm, 0mm, 1.65mm) x=(1mm, 0mm, 0mm) y=(0mm, 1mm, 0mm) in RelativeCS28
  coordinate_system RelativeCS30 = origin=(0.1mm, 0mm, 0mm) x=(1mm, 0mm, 0mm) y=(0mm, 1mm, 0mm) in RelativeCS29
  Cylinder7 = cylinder(axis=X, base_centre=(0mm, 0mm, -1.55mm), radius=0.1mm, height=0.1mm) in RelativeCS30
  Antenna.unite(Cylinder7)
  coordinate_system RelativeCS33 = origin=(50mm, 0mm, -0.05005mm) x=(1mm, 0mm, 0mm) y=(0mm, 1mm, 0mm) in RelativeCS22
  coordinate_system RelativeCS34 = origin=(0mm, 0mm, 0.05mm) x=(1mm, 0mm, 0mm) y=(0mm, 1mm, 0mm) in RelativeCS33
  point Point2 = (0mm, 0mm, 6mm) in RelativeCS34
  group probes = FieldProbe
boundaries and excitations:
  PerfE1: Perfect E Objects=[Rectangle1, Rectangle1_1, Rectangle2, Rectangle2_1]
  Open1: Radiation Objects=RadiatingSurface
  waveport1: Wave Port Objects=Rectangle4_1 WavePortType=Modal NumModes=1 Modes{Mode1{CharImp=Zpi}}
  waveport2: Wave Port Objects=Rectangle4 WavePortType=Modal NumModes=1 Modes{Mode1{CharImp=Zpi}}
  antenna: Wave Port Objects=Circle2 WavePortType=Modal NumModes=1 Modes{Mode1{IntLine{(0.9, 0.14142136, 12) -> (0.8, 0.14142136, 12)} CharImp=Zpi}}
setups:
  Setup1: HfssDriven Frequency=1GHz MaxDeltaS=0.002 MaximumPasses=10 MinimumPasses=1 MinimumConvergedPasses=1 PercentRefinement=30 BasisOrder=1 PortAccuracy=2 DrivenSolverType="Direct Solver"
    sweep Sweep: 100MHz to 1GHz, 401 points; Type=Interpolating SaveFields InterpTolerance=0.5 InterpMaxSolns=250 InterpUsePortImped=false PassivityErrorTolerance=0.0001
source amplitudes:
  waveport1:1, waveport2:1: 0W 0deg
  antenna:1: 127770.394175039W 0deg
field calculator expressions:
  Ex = Fundamental_Quantity(0) | ScalarX | CmplxMag
  Ey = Fundamental_Quantity(0) | ScalarY | CmplxMag
  Ez = Fundamental_Quantity(0) | ScalarZ | CmplxMag
field plots:
  Vector_H1: H Field over FieldProbe.face on Setup1 : LastAdaptive at Freq=1GHz Phase=0deg
  Vector_H2: H Field over Rectangle5.face on Setup1 : LastAdaptive at Freq=1GHz Phase=0deg
  Vector_Jsurf1: Jsurf over Rectangle3 on Setup1 : LastAdaptive at Freq=1GHz Phase=0deg
  Mag_E1: E Field over Rectangle4_1.face on Setup1 : LastAdaptive at Freq=1GHz Phase=0deg
reports:
  Forward Transmission Coefficient Antenna Waveport: dB(S(waveport1:1,antenna)) vs Freq on Setup1 : Sweep [alphaXY=all yOffset=all zOffset=all]
  Coupling Waveport2 Antenna: dB(S(waveport2:1,antenna)) vs Freq on Setup1 : Sweep [alphaXY=all yOffset=all zOffset=all]
  Comparison Mode1: dB(S(waveport1:1,antenna)), dB(S(waveport2:1,antenna)) vs Freq on Setup1 : Sweep [alphaXY=all yOffset=all zOffset=all]
  Phase Shifts Antenna Waveports: ang_rad(S(waveport2,antenna)), ang_rad(S(waveport1,antenna)) vs Freq on Setup1 : Sweep; markers m1 at 1GHz, m2 at 1GHz

design Dipole Moments (HFSS, HFSS Modal Network, model units mm)
variables:
  b = 12mm  # 17
  w = 30mm/2  # 27/2
  a = 20mm  # 20
  length = 100mm  # 100
  t = 0.1mm  # 0.1
  Y0 = 0mm
  Z0 = b/2
  alphaXY = 0deg
  alphaXZ = 0deg
  yOffset = 0mm
  zOffset = 0mm
geometry:
  Rectangle1 = rectangle(corner=(-length/2, -a, b), x_size=length, y_size=2*a)
  Rectangle1_1 = Rectangle1.duplicate_around_axis(axis=X, angle=180deg, total=2)
  Rectangle2 = rectangle(corner=(-length/2, -a, -b), z_size=2*b, x_size=length)
  Rectangle2_1 = Rectangle2.duplicate_around_axis(axis=X, angle=180deg, total=2)
  Rectangle3 [copper, solve inside] = rectangle(corner=(-length/2, -w, (-t/2) mm), x_size=length, y_size=2*w)
  Rectangle3.thicken(t, both sides)
  Rectangle4 = rectangle(corner=(-length/2, -a, -b), y_size=2*a, z_size=2*b)
  Rectangle4_1 = Rectangle4.duplicate_around_axis(axis=Z, angle=180deg, total=2)
  Box1 [vacuum] = box(corner=(-length/2, -a, -b), size=(length, 2*a, 2*b))
  RadiatingSurface [vacuum] = region(absolute_offset: +X=0mm, -X=0mm, +Y=10mm, -Y=10mm, +Z=10mm, -Z=10mm)
  FieldProbe = Rectangle1.duplicate_along_line(step=(0mm, 0mm, -b/2), total=2)
  coordinate_system RelativeCS9 = origin=(-75mm, 100mm, -100mm) x=(1mm, 0mm, 0mm) y=(0mm, 1mm, 0mm)
  coordinate_system RelativeCS10 = origin=(0mm, 0mm, -60mm) x=(1mm, 0mm, 0mm) y=(0mm, 1mm, 0mm) in RelativeCS9
  coordinate_system RelativeCS11 = origin=(235mm, 130mm, 0mm) x=(1mm, 0mm, 0mm) y=(0mm, 1mm, 0mm) in RelativeCS10
  coordinate_system RelativeCS12 = origin=(-85mm, -165mm, 110.5mm) x=(1mm, 0mm, 0mm) y=(0mm, 1mm, 0mm) in RelativeCS11
  coordinate_system RelativeCS13 = origin=(-75mm, -65mm, 49.5mm) x=(1mm, 0mm, 0mm) y=(0mm, 1mm, 0mm) in RelativeCS12
  coordinate_system RelativeCS14 = origin=(235mm, 130mm, 0mm) x=(1mm, 0mm, 0mm) y=(0mm, 1mm, 0mm) in RelativeCS13
  coordinate_system RelativeCS15 = origin=(-85mm, -165mm, 110.5mm) x=(1mm, 0mm, 0mm) y=(0mm, 1mm, 0mm) in RelativeCS14
  coordinate_system RelativeCS16 = origin=(1mm, 0.14142136mm, 10.35mm) x=(1mm, 0mm, 0mm) y=(0mm, 1mm, 0mm)
  coordinate_system RelativeCS17 = origin=(-0.1mm, 0mm, 1.65mm) x=(1mm, 0mm, 0mm) y=(0mm, 1mm, 0mm) in RelativeCS16
  coordinate_system RelativeCS18 = origin=(0.1mm, 0mm, 0mm) x=(1mm, 0mm, 0mm) y=(0mm, 1mm, 0mm) in RelativeCS17
  Circle1 = circle(normal=Z, centre=(0mm, 0mm, -1.55mm), radius=0.2mm) in RelativeCS18
  Rectangle1.subtract(Circle1)
  Cylinder6 = cylinder(axis=Z, base_centre=(0mm, 0mm, 0mm), radius=0.2mm, height=0.1mm) in RelativeCS18
  Rectangle1.subtract(Cylinder6)
  Circle2 = circle(normal=Z, centre=(0mm, 0mm, 0mm), radius=0.2mm) in RelativeCS18
  Circle3 = circle(normal=Z, centre=(0mm, 0mm, -1.55mm), radius=0.1mm) in RelativeCS18
  Circle2.subtract(Circle3)
  Circle4 = circle(normal=Z, centre=(0mm, 0mm, 0mm), radius=0.1mm) in RelativeCS18
  Circle2.subtract(Circle4)
  pecCap1 [pec] = object_from(Circle2.edge(1 of 1))
  pecCap1.thicken(0.05mm)
  Rectangle5 = rectangle(corner=(-1mm, 19.858579mm, 0mm), y_size=-40mm, z_size=-24mm) in RelativeCS18
  coordinate_system RelativeCS19 = origin=(1.1mm, 0mm, -1.5mm) x=(1mm, 0mm, 0mm) y=(0mm, 1mm, 0mm) in RelativeCS18
  coordinate_system RelativeCS20 = origin=(-1.1mm, 0mm, 1.55mm) x=(1mm, 0mm, 0mm) y=(0mm, 1mm, 0mm) in RelativeCS19
  point Point1 = (-200mm, 0mm, 25mm)
  point Point2 = (200mm, 0mm, 25.104167mm)
  point Point3 = (-50mm, 0mm, 6mm)
  group probes = FieldProbe
boundaries and excitations:
  PerfE1: Perfect E Objects=[Rectangle1, Rectangle1_1, Rectangle2, Rectangle2_1]
  Open1: Radiation Objects=RadiatingSurface
  elec_dipole: Hertzian-Dipole Incident Wave IsCartesian EoX=0 EoY=0 EoZ=1 kX=0 kY=0 kZ=1 OriginX=0mm OriginY=0mm OriginZ=6mm SphereRadius=0.001mm IsElectricDipole=true
  mag_dipole: Hertzian-Dipole Incident Wave IsCartesian EoX=0 EoY=1 EoZ=0 kX=0 kY=0 kZ=1 OriginX=0mm OriginY=0mm OriginZ=6mm SphereRadius=0.001mm IsElectricDipole=false
  waveport1: Wave Port Objects=Rectangle4_1 WavePortType=Modal NumModes=1 Modes{Mode1{CharImp=Zpi}}
  waveport2: Wave Port Objects=Rectangle4 WavePortType=Modal NumModes=1 Modes{Mode1{CharImp=Zpi}}
setups:
  Setup1: HfssDriven Frequency=1GHz MaxDeltaS=0.002 MaximumPasses=10 MinimumPasses=1 MinimumConvergedPasses=1 PercentRefinement=30 BasisOrder=1 PortAccuracy=2 DrivenSolverType="Direct Solver"
    sweep Sweep: 100MHz to 1GHz, 401 points; Type=Interpolating SaveFields InterpTolerance=0.5 InterpMaxSolns=250 InterpUsePortImped=false PassivityErrorTolerance=0.0001
source amplitudes:
  waveport1:1, waveport2:1: 0W 0deg
  elec_dipole:1: 0.00048197 90deg
  mag_dipole:1: 0.00646507Vm 0deg
field calculator expressions:
  Ex = Fundamental_Quantity(0) | ScalarX | CmplxMag
  Ey = Fundamental_Quantity(0) | ScalarY | CmplxMag
  Ez = Fundamental_Quantity(0) | ScalarZ | CmplxMag
field plots:
  Vector_E1: E Field over FieldProbe.face on Setup1 : LastAdaptive at Freq=1GHz Phase=0deg
  Vector_H1: H Field over FieldProbe.face on Setup1 : LastAdaptive at Freq=1GHz Phase=0deg
  Vector_E2: E Field over Rectangle5.face on Setup1 : LastAdaptive at Freq=1GHz Phase=0deg
  Vector_H2: H Field over Rectangle5.face on Setup1 : LastAdaptive at Freq=1GHz Phase=0deg
  Vector_Jsurf1: Jsurf over Rectangle3 on Setup1 : LastAdaptive at Freq=1GHz Phase=0deg
reports:
  Coupling Waveport1 to Antenna: dB(S(waveport1:1,antenna)), dB(S(waveport1:2,antenna)), dB(S(waveport1:3,antenna)) vs Freq on Setup1 : Sweep [alphaXY=all yOffset=all zOffset=all]; markers MX1 at x=1e+08, MX2 at x=5.4934593e+08
  Coupling Waveport2 Antenna: dB(S(waveport2:1,antenna)), dB(S(waveport2:2,antenna)), dB(S(waveport2:3,antenna)) vs Freq on Setup1 : Sweep [alphaXY=all yOffset=all zOffset=all]
  Comparison Mode1: dB(S(waveport1:1,antenna)), dB(S(waveport2:1,antenna)) vs Freq on Setup1 : Sweep [alphaXY=all yOffset=all zOffset=all]
  Comparison Mode2: dB(S(waveport1:2,antenna)), dB(S(waveport2:2,antenna)) vs Freq on Setup1 : Sweep [alphaXY=all yOffset=all zOffset=all]
  Comparison Mode3: dB(S(waveport1:3,antenna)), dB(S(waveport2:3,antenna)) vs Freq on Setup1 : Sweep [alphaXY=all yOffset=all zOffset=all]
  Phase Shift Waveports: ang_rad(S(waveport2:1,antenna)), ang_rad(S(waveport1:1,antenna)) vs Freq on Setup1 : Sweep; markers m1 at 0.1GHz, m2 at 0.1GHz, m3 at 0.55GHz, m4 at 0.55GHz, MX1 at x=1e+08
