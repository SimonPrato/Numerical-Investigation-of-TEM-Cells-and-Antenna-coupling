# Ansys Electronics Desktop project, version 2025.1
project variables:
  $GndPinXxX = 1mm
  $GndPadXxX = 6mm
  $GndPinLength = 1mm
  $PinLength = 1mm
  $AntPadStep = 0.1mm
  $Diameter1 = 1.3mm
  $AntiPadDiameter = 4mm
  $GndPadHigth = 1mm
  $Diameter2 = 4.35mm
  $ConnectorHight = 4.5mm
  $Diameter3 = 5mm
  $freq = 0MHz
materials:
  copper: permeability=0.999991 conductivity=58000000
  vacuum: permittivity=1
  FR4_epoxy: permittivity=4.4 permeability=1 dielectric_loss_tangent=0.02
  Teflon (tm): permittivity=2.1 dielectric_loss_tangent=0.001
  gold: permeability=0.99996 conductivity=41000000
  pec: conductivity=1e+30
  perfect conductor: conductivity=1e+30

design monopole (HFSS, HFSS Modal Network, model units mm)
variables:
  b = 12mm  # 17
  w = 30mm/2  # 27/2
  a = 20mm  # 20
  length = 100mm  # 100
  t = 0.1mm  # 0.1
  antenna_height = 2mm
  current_loop_radius = 0.101mm
  antenna_wire_radius = 0.1mm
  antenna_offset = 0mm
  pos_loop_1 = 9
geometry:
  upper_cell_wall = rectangle(corner=(-length/2, -a, b), x_size=length, y_size=2*a)
  lower_cell_wall = upper_cell_wall.duplicate_around_axis(axis=X, angle=180deg, total=2)
  side_wall_1 = rectangle(corner=(-length/2, -a, -b), z_size=2*b, x_size=length)
  side_wall_2 = side_wall_1.duplicate_around_axis(axis=X, angle=180deg, total=2)
  Septum [perfect conductor] = rectangle(corner=(-length/2, -w, (-t/2) mm), x_size=length, y_size=2*w)
  Septum.thicken(t, both sides)
  waveport2 = rectangle(corner=(-length/2, -a, -b), y_size=2*a, z_size=2*b)
  waveport1 = waveport2.duplicate_around_axis(axis=Z, angle=180deg, total=2)
  TEM_Cell_Confinement [vacuum] = box(corner=(-length/2, -a, -b), size=(length, 2*a, 2*b))
  RadiatingSurface [vacuum] = region(absolute_offset: +X=0mm, -X=0mm, +Y=10mm, -Y=10mm, +Z=10mm, -Z=10mm)
  coordinate_system RelativeCS9 = origin=(-75mm, 100mm, -100mm) x=(1mm, 0mm, 0mm) y=(0mm, 1mm, 0mm)
  coordinate_system RelativeCS10 = origin=(0mm, 0mm, -60mm) x=(1mm, 0mm, 0mm) y=(0mm, 1mm, 0mm) in RelativeCS9
  coordinate_system RelativeCS11 = origin=(235mm, 130mm, 0mm) x=(1mm, 0mm, 0mm) y=(0mm, 1mm, 0mm) in RelativeCS10
  coordinate_system RelativeCS12 = origin=(-85mm, -165mm, 110.5mm) x=(1mm, 0mm, 0mm) y=(0mm, 1mm, 0mm) in RelativeCS11
  coordinate_system RelativeCS13 = origin=(-75mm, -65mm, 49.5mm) x=(1mm, 0mm, 0mm) y=(0mm, 1mm, 0mm) in RelativeCS12
  coordinate_system RelativeCS14 = origin=(235mm, 130mm, 0mm) x=(1mm, 0mm, 0mm) y=(0mm, 1mm, 0mm) in RelativeCS13
  coordinate_system RelativeCS15 = origin=(-85mm, -165mm, 110.5mm) x=(1mm, 0mm, 0mm) y=(0mm, 1mm, 0mm) in RelativeCS14
  coordinate_system RelativeCS16 = origin=(1mm, 0.14142136mm, 10.35mm) x=(1mm, 0mm, 0mm) y=(0mm, 1mm, 0mm)
  coordinate_system RelativeCS17 = origin=(-0.1mm, 0mm, 1.65mm) x=(1mm, 0mm, 0mm) y=(0mm, 1mm, 0mm) in RelativeCS16
  coordinate_system RelativeCS18 = origin=(0.1mm, 0mm, 0mm) x=(1mm, 0mm, 0mm) y=(0mm, 1mm, 0mm) in RelativeCS17
  coordinate_system RelativeCS38 = origin=(-14.8mm, 3.2mm, 0mm) x=(1mm, 0mm, 0mm) y=(0mm, 1mm, 0mm) in RelativeCS37
  coordinate_system RelativeCS39 = origin=(-58.2mm, 26.541421mm, 0.05mm) x=(1mm, 0mm, 0mm) y=(0mm, 1mm, 0mm) in RelativeCS38
  coordinate_system RelativeCS40 = origin=(61.4mm, -27.8mm, 0mm) x=(1mm, 0mm, 0mm) y=(0mm, 1mm, 0mm) in RelativeCS39
  coordinate_system RelativeCS41 = origin=(-61.4mm, 27.8mm, -0.05mm) x=(1mm, 0mm, 0mm) y=(0mm, 1mm, 0mm) in RelativeCS40
  coordinate_system RelativeCS42 = origin=(4mm, 0mm, 0mm) x=(1mm, 0mm, 0mm) y=(0mm, 1mm, 0mm) in RelativeCS41
  coordinate_system RelativeCS43 = origin=(-4mm, 0mm, 0mm) x=(1mm, 0mm, 0mm) y=(0mm, 1mm, 0mm) in RelativeCS42
  coordinate_system RelativeCS44 = origin=((-0.70000000000001+0.7) mm, -0.005mm, 0mm) x=(1mm, 0mm, 0mm) y=(0mm, 1mm, 0mm) in RelativeCS43
  Cylinder6 = cylinder(axis=Z, base_centre=(0mm, antenna_offset, 0mm), radius=0.2mm, height=0.1mm) in RelativeCS44
  upper_cell_wall.subtract(Cylinder6)
  antenna_port = circle(normal=Z, centre=(0mm, 0mm, 0mm), radius=0.2mm) in RelativeCS44
  Circle3 = circle(normal=Z, centre=(0mm, 0mm, -1.55mm), radius=0.1mm) in RelativeCS18
  antenna_port.subtract(Circle3)
  Circle4 = circle(normal=Z, centre=(0mm, 0mm, 0mm), radius=0.1mm) in RelativeCS18
  antenna_port.subtract(Circle4)
  antenna_port_cap [pec] = object_from(antenna_port.edge(1 of 1))
  antenna_port_cap.thicken(0.05mm)
  coordinate_system RelativeCS19 = origin=(1.1mm, 0mm, -1.5mm) x=(1mm, 0mm, 0mm) y=(0mm, 1mm, 0mm) in RelativeCS18
  coordinate_system RelativeCS20 = origin=(-1.1mm, 0mm, 1.55mm) x=(1mm, 0mm, 0mm) y=(0mm, 1mm, 0mm) in RelativeCS19
  coordinate_system RelativeCS21 = origin=(-50mm, 0mm, 12mm) x=(1mm, 0mm, 0mm) y=(0mm, 1mm, 0mm)
  point Point_Waveport2 = (0mm, 0mm, -6mm) in RelativeCS21
  coordinate_system RelativeCS22 = origin=(50mm, 0mm, -12mm) x=(1mm, 0mm, 0mm) y=(0mm, 1mm, 0mm) in RelativeCS21
  coordinate_system RelativeCS31 = origin=(-75mm, 100mm, -100mm) x=(1mm, 0mm, 0mm) y=(0mm, 1mm, 0mm) in RelativeCS22
  coordinate_system RelativeCS32 = origin=(0mm, 0mm, -60mm) x=(1mm, 0mm, 0mm) y=(0mm, 1mm, 0mm) in RelativeCS31
  coordinate_system RelativeCS23 = origin=(235mm, 130mm, 0mm) x=(1mm, 0mm, 0mm) y=(0mm, 1mm, 0mm) in RelativeCS32
  coordinate_system RelativeCS24 = origin=(-85mm, -165mm, 110.5mm) x=(1mm, 0mm, 0mm) y=(0mm, 1mm, 0mm) in RelativeCS23
  coordinate_system RelativeCS25 = origin=(-75mm, -65mm, 49.5mm) x=(1mm, 0mm, 0mm) y=(0mm, 1mm, 0mm) in RelativeCS24
  coordinate_system RelativeCS26 = origin=(235mm, 130mm, 0mm) x=(1mm, 0mm, 0mm) y=(0mm, 1mm, 0mm) in RelativeCS25
  coordinate_system RelativeCS27 = origin=(-85mm, -165mm, 110.5mm) x=(1mm, 0mm, 0mm) y=(0mm, 1mm, 0mm) in RelativeCS26
  coordinate_system RelativeCS28 = origin=(1mm, 0.14142136mm, 10.35mm) x=(1mm, 0mm, 0mm) y=(0mm, 1mm, 0mm) in RelativeCS22
  coordinate_system RelativeCS29 = origin=(-0.1mm, 0mm, 1.65mm) x=(1mm, 0mm, 0mm) y=(0mm, 1mm, 0mm) in RelativeCS28
  coordinate_system RelativeCS30 = origin=(0.1mm, 0mm, 0mm) x=(1mm, 0mm, 0mm) y=(0mm, 1mm, 0mm) in RelativeCS29
  coordinate_system RelativeCS33 = origin=(50mm, 0mm, -0.05005mm) x=(1mm, 0mm, 0mm) y=(0mm, 1mm, 0mm) in RelativeCS22
  coordinate_system RelativeCS34 = origin=(0mm, 0mm, 0.05mm) x=(1mm, 0mm, 0mm) y=(0mm, 1mm, 0mm) in RelativeCS33
  point Point_Waveport1 = (0mm, 0mm, 6mm) in RelativeCS34
  coordinate_system RelativeCS35 = origin=(-49mm, 0.14142136mm, 12.00005mm) x=(1mm, 0mm, 0mm) y=(0mm, 1mm, 0mm) in RelativeCS34
  coordinate_system RelativeCS36 = origin=(-1mm, -0.14142136mm, 0mm) x=(1mm, 0mm, 0mm) y=(0mm, 1mm, 0mm) in RelativeCS35
  coordinate_system RelativeCS37 = origin=(73mm, -29.6mm, 0mm) x=(1mm, 0mm, 0mm) y=(0mm, 1mm, 0mm) in RelativeCS36
  Antenna [perfect conductor] = cylinder(axis=Z, base_centre=(0mm, 0mm, 0mm), radius=antenna_wire_radius, height=-antenna_height) in RelativeCS44
  current_loop_1 = circle(normal=Z, centre=(0mm, 0mm, 0mm), radius=current_loop_radius) in RelativeCS44
  Antenna.move(0mm, antenna_offset, 0mm) in RelativeCS44
  current_loop_1.move(0mm, antenna_offset, (-antenna_height+antenna_wire_radius)/9*pos_loop_1) in RelativeCS44
  [antenna_port_cap, antenna_port].move(0mm, antenna_offset, 0mm) in RelativeCS44
boundaries and excitations:
  PerfE1: Perfect E Objects=[upper_cell_wall, lower_cell_wall, side_wall_1, side_wall_2]
  Open1: Radiation Objects=RadiatingSurface
  waveport1: Wave Port Objects=waveport1 WavePortType=Modal NumModes=1 Modes{Mode1{CharImp=Zpi}}
  waveport2: Wave Port Objects=waveport2 WavePortType=Modal NumModes=1 Modes{Mode1{CharImp=Zpi}}
  antenna: Wave Port Objects=antenna_port WavePortType=Modal NumModes=1 Modes{Mode1{CharImp=Zpi RenormImp=50ohm}}
setups:
  Setup1: HfssDriven Frequency=3GHz MaxDeltaS=0.002 MaximumPasses=10 MinimumPasses=1 MinimumConvergedPasses=1 PercentRefinement=30 BasisOrder=1 PortAccuracy=2 DrivenSolverType="Direct Solver"
    sweep Sweep: 1MHz to 3GHz, 401 points; Type=Interpolating SaveFields InterpTolerance=0.5 InterpMaxSolns=250 InterpUsePortImped=false PassivityErrorTolerance=0.0001
source amplitudes:
  waveport1:1, waveport2:1: 0W 0deg
  antenna:1: 1000000W 0deg
field calculator expressions:
  current_loop1_real = <Hx,Hy,Hz> | Real | Tangent | Dot | EnterLine(current_loop_1) | LineValue | Integrate
  current_loop1_imag = <Hx,Hy,Hz> | Imag | Tangent | Dot | EnterLine(current_loop_1) | LineValue | Integrate
reports:
  Forward Transmission Coefficient Antenna Waveport: dB(S(waveport1:1,antenna)) vs Freq on Setup1 : Sweep
  Phase Shifts Antenna Waveports: ang_rad(S(waveport2,antenna)), ang_rad(S(waveport1,antenna)) vs Freq on Setup1 : Sweep; markers m1 at 1GHz, m2 at 1GHz
  Current Along Antenna: sqrt(current_loop1_real*current_loop1_real+current_loop1_imag*current_loop1_imag) vs pos_loop_1 on Setup1 : LastAdaptive [Phase=0deg Freq=1GHz current_loop_radius=all]

design inverted_f (HFSS, HFSS Modal Network, model units mm)
variables:
  b = 12mm  # 17
  w = 30mm/2  # 27/2
  a = 20mm  # 20
  length = 100mm  # 100
  t = 0.1mm  # 0.1
  antenna_width = 1.9mm
  current_loop_radius = 0.101mm
  antenna_wire_radius = 0.1mm
  feedpoint_height = 1.8mm
  bar_height = 1.8mm
  antenna_rotation_angle = 45deg
  antenna_offset = 1mm
  pos_loop1 = 1
  pos_loop2 = 1
  pos_loop4 = 1
  pos_loop3 = 1
geometry:
  upper_cell_wall = rectangle(corner=(-length/2, -a, b), x_size=length, y_size=2*a)
  lower_cell_wall = upper_cell_wall.duplicate_around_axis(axis=X, angle=180deg, total=2)
  side_wall_1 = rectangle(corner=(-length/2, -a, -b), z_size=2*b, x_size=length)
  side_wall_2 = side_wall_1.duplicate_around_axis(axis=X, angle=180deg, total=2)
  Septum [perfect conductor] = rectangle(corner=(-length/2, -w, (-t/2) mm), x_size=length, y_size=2*w)
  Septum.thicken(t, both sides)
  waveport2 = rectangle(corner=(-length/2, -a, -b), y_size=2*a, z_size=2*b)
  waveport1 = waveport2.duplicate_around_axis(axis=Z, angle=180deg, total=2)
  TEM_Cell_Confinement [vacuum] = box(corner=(-length/2, -a, -b), size=(length, 2*a, 2*b))
  RadiatingSurface [vacuum] = region(absolute_offset: +X=0mm, -X=0mm, +Y=10mm, -Y=10mm, +Z=10mm, -Z=10mm)
  coordinate_system RelativeCS9 = origin=(-75mm, 100mm, -100mm) x=(1mm, 0mm, 0mm) y=(0mm, 1mm, 0mm)
  coordinate_system RelativeCS10 = origin=(0mm, 0mm, -60mm) x=(1mm, 0mm, 0mm) y=(0mm, 1mm, 0mm) in RelativeCS9
  coordinate_system RelativeCS11 = origin=(235mm, 130mm, 0mm) x=(1mm, 0mm, 0mm) y=(0mm, 1mm, 0mm) in RelativeCS10
  coordinate_system RelativeCS12 = origin=(-85mm, -165mm, 110.5mm) x=(1mm, 0mm, 0mm) y=(0mm, 1mm, 0mm) in RelativeCS11
  coordinate_system RelativeCS13 = origin=(-75mm, -65mm, 49.5mm) x=(1mm, 0mm, 0mm) y=(0mm, 1mm, 0mm) in RelativeCS12
  coordinate_system RelativeCS14 = origin=(235mm, 130mm, 0mm) x=(1mm, 0mm, 0mm) y=(0mm, 1mm, 0mm) in RelativeCS13
  coordinate_system RelativeCS15 = origin=(-85mm, -165mm, 110.5mm) x=(1mm, 0mm, 0mm) y=(0mm, 1mm, 0mm) in RelativeCS14
  coordinate_system RelativeCS16 = origin=(1mm, 0.14142136mm, 10.35mm) x=(1mm, 0mm, 0mm) y=(0mm, 1mm, 0mm)
  coordinate_system RelativeCS17 = origin=(-0.1mm, 0mm, 1.65mm) x=(1mm, 0mm, 0mm) y=(0mm, 1mm, 0mm) in RelativeCS16
  coordinate_system RelativeCS18 = origin=(0.1mm, 0mm, 0mm) x=(1mm, 0mm, 0mm) y=(0mm, 1mm, 0mm) in RelativeCS17
  coordinate_system RelativeCS38 = origin=(-14.8mm, 3.2mm, 0mm) x=(1mm, 0mm, 0mm) y=(0mm, 1mm, 0mm) in RelativeCS37
  coordinate_system RelativeCS39 = origin=(-58.2mm, 26.541421mm, 0.05mm) x=(1mm, 0mm, 0mm) y=(0mm, 1mm, 0mm) in RelativeCS38
  coordinate_system RelativeCS40 = origin=(61.4mm, -27.8mm, 0mm) x=(1mm, 0mm, 0mm) y=(0mm, 1mm, 0mm) in RelativeCS39
  coordinate_system RelativeCS41 = origin=(-61.4mm, 27.8mm, -0.05mm) x=(1mm, 0mm, 0mm) y=(0mm, 1mm, 0mm) in RelativeCS40
  coordinate_system RelativeCS42 = origin=(4mm, 0mm, 0mm) x=(1mm, 0mm, 0mm) y=(0mm, 1mm, 0mm) in RelativeCS41
  coordinate_system RelativeCS43 = origin=(-4mm, 0mm, 0mm) x=(1mm, 0mm, 0mm) y=(0mm, 1mm, 0mm) in RelativeCS42
  coordinate_system RelativeCS44 = origin=((-0.70000000000001+0.7) mm, -0.005mm, 0mm) x=(1mm, 0mm, 0mm) y=(0mm, 1mm, 0mm) in RelativeCS43
  Cylinder6 = cylinder(axis=Z, base_centre=(0mm, antenna_offset, 0mm), radius=0.2mm, height=0.1mm) in RelativeCS44
  upper_cell_wall.subtract(Cylinder6)
  antenna_port = circle(normal=Z, centre=(0mm, 0mm, 0mm), radius=0.2mm) in RelativeCS44
  Circle3 = circle(normal=Z, centre=(0mm, 0mm, -1.55mm), radius=0.1mm) in RelativeCS18
  antenna_port.subtract(Circle3)
  Circle4 = circle(normal=Z, centre=(0mm, 0mm, 0mm), radius=0.1mm) in RelativeCS18
  antenna_port.subtract(Circle4)
  antenna_port_cap [pec] = object_from(antenna_port.edge(1 of 1))
  antenna_port_cap.thicken(0.05mm)
  coordinate_system RelativeCS19 = origin=(1.1mm, 0mm, -1.5mm) x=(1mm, 0mm, 0mm) y=(0mm, 1mm, 0mm) in RelativeCS18
  coordinate_system RelativeCS20 = origin=(-1.1mm, 0mm, 1.55mm) x=(1mm, 0mm, 0mm) y=(0mm, 1mm, 0mm) in RelativeCS19
  coordinate_system RelativeCS21 = origin=(-50mm, 0mm, 12mm) x=(1mm, 0mm, 0mm) y=(0mm, 1mm, 0mm)
  point Point1 = (0mm, 0mm, -6mm) in RelativeCS21
  coordinate_system RelativeCS22 = origin=(50mm, 0mm, -12mm) x=(1mm, 0mm, 0mm) y=(0mm, 1mm, 0mm) in RelativeCS21
  coordinate_system RelativeCS31 = origin=(-75mm, 100mm, -100mm) x=(1mm, 0mm, 0mm) y=(0mm, 1mm, 0mm) in RelativeCS22
  coordinate_system RelativeCS32 = origin=(0mm, 0mm, -60mm) x=(1mm, 0mm, 0mm) y=(0mm, 1mm, 0mm) in RelativeCS31
  coordinate_system RelativeCS23 = origin=(235mm, 130mm, 0mm) x=(1mm, 0mm, 0mm) y=(0mm, 1mm, 0mm) in RelativeCS32
  coordinate_system RelativeCS24 = origin=(-85mm, -165mm, 110.5mm) x=(1mm, 0mm, 0mm) y=(0mm, 1mm, 0mm) in RelativeCS23
  coordinate_system RelativeCS25 = origin=(-75mm, -65mm, 49.5mm) x=(1mm, 0mm, 0mm) y=(0mm, 1mm, 0mm) in RelativeCS24
  coordinate_system RelativeCS26 = origin=(235mm, 130mm, 0mm) x=(1mm, 0mm, 0mm) y=(0mm, 1mm, 0mm) in RelativeCS25
  coordinate_system RelativeCS27 = origin=(-85mm, -165mm, 110.5mm) x=(1mm, 0mm, 0mm) y=(0mm, 1mm, 0mm) in RelativeCS26
  coordinate_system RelativeCS28 = origin=(1mm, 0.14142136mm, 10.35mm) x=(1mm, 0mm, 0mm) y=(0mm, 1mm, 0mm) in RelativeCS22
  coordinate_system RelativeCS29 = origin=(-0.1mm, 0mm, 1.65mm) x=(1mm, 0mm, 0mm) y=(0mm, 1mm, 0mm) in RelativeCS28
  coordinate_system RelativeCS30 = origin=(0.1mm, 0mm, 0mm) x=(1mm, 0mm, 0mm) y=(0mm, 1mm, 0mm) in RelativeCS29
  coordinate_system RelativeCS33 = origin=(50mm, 0mm, -0.05005mm) x=(1mm, 0mm, 0mm) y=(0mm, 1mm, 0mm) in RelativeCS22
  coordinate_system RelativeCS34 = origin=(0mm, 0mm, 0.05mm) x=(1mm, 0mm, 0mm) y=(0mm, 1mm, 0mm) in RelativeCS33
  point Point2 = (0mm, 0mm, 6mm) in RelativeCS34
  coordinate_system RelativeCS35 = origin=(-49mm, 0.14142136mm, 12.00005mm) x=(1mm, 0mm, 0mm) y=(0mm, 1mm, 0mm) in RelativeCS34
  coordinate_system RelativeCS36 = origin=(-1mm, -0.14142136mm, 0mm) x=(1mm, 0mm, 0mm) y=(0mm, 1mm, 0mm) in RelativeCS35
  coordinate_system RelativeCS37 = origin=(73mm, -29.6mm, 0mm) x=(1mm, 0mm, 0mm) y=(0mm, 1mm, 0mm) in RelativeCS36
  Antenna [perfect conductor] = cylinder(axis=Z, base_centre=(0mm, 0mm, 0mm), radius=antenna_wire_radius, height=-feedpoint_height) in RelativeCS44
  Cylinder8 = cylinder(axis=X, base_centre=(-antenna_wire_radius, 0mm, -feedpoint_height), radius=antenna_wire_radius, height=antenna_width) in RelativeCS44
  Cylinder9 = cylinder(axis=Z, base_centre=(antenna_width-antenna_wire_radius, 0mm, -feedpoint_height-antenna_wire_radius), radius=antenna_wire_radius, height=feedpoint_height+antenna_wire_radius) in RelativeCS44
  Antenna.unite(Cylinder8, Cylinder9)
  current_loop_1 = circle(normal=Z, centre=(0mm, 0mm, 0mm), radius=current_loop_radius) in RelativeCS44
  current_loop_2 = circle(normal=X, centre=(antenna_wire_radius+(antenna_width-3*antenna_wire_radius)/9*pos_loop2, 0mm, -feedpoint_height), radius=current_loop_radius) in RelativeCS44
  current_loop_3 = circle(normal=Z, centre=(antenna_width-antenna_wire_radius, 0mm, -feedpoint_height+antenna_wire_radius+(feedpoint_height-antenna_wire_radius)/9*pos_loop3), radius=current_loop_radius) in RelativeCS44
  Cylinder10 = cylinder(axis=X, base_centre=(0mm, 0mm, -feedpoint_height), radius=antenna_wire_radius, height=-bar_height) in RelativeCS44
  Antenna.unite(Cylinder10)
  current_loop_4 = circle(normal=X, centre=(-antenna_wire_radius+-(bar_height-antenna_wire_radius)/9 *pos_loop4, 0mm, -feedpoint_height), radius=current_loop_radius) in RelativeCS44
  [Antenna, current_loop_1..current_loop_4].rotate(axis=Z, angle=antenna_rotation_angle) in RelativeCS44
  [Antenna, antenna_port, antenna_port_cap].move(0mm, antenna_offset, 0mm) in RelativeCS44
  current_loop_1.move(0mm, antenna_offset, (-feedpoint_height+antenna_wire_radius)/9*pos_loop1) in RelativeCS44
  [current_loop_2, current_loop_3, current_loop_4].move(0mm, antenna_offset, 0mm) in RelativeCS44
boundaries and excitations:
  PerfE1: Perfect E Objects=[upper_cell_wall, lower_cell_wall, side_wall_1, side_wall_2]
  Open1: Radiation Objects=RadiatingSurface
  waveport1: Wave Port Objects=waveport1 WavePortType=Modal NumModes=1 Modes{Mode1{CharImp=Zpi}}
  waveport2: Wave Port Objects=waveport2 WavePortType=Modal NumModes=1 Modes{Mode1{CharImp=Zpi}}
  antenna: Wave Port Objects=antenna_port WavePortType=Modal NumModes=1 Modes{Mode1{CharImp=Zpi RenormImp=50ohm}}
setups:
  Setup1: HfssDriven Frequency=3GHz MaxDeltaS=0.002 MaximumPasses=10 MinimumPasses=1 MinimumConvergedPasses=1 PercentRefinement=30 BasisOrder=1 PortAccuracy=2 DrivenSolverType="Direct Solver"
    sweep Sweep: 1MHz to 3GHz, 401 points; Type=Interpolating SaveFields InterpTolerance=0.5 InterpMaxSolns=250 InterpUsePortImped=false PassivityErrorTolerance=0.0001
source amplitudes:
  waveport1:1, waveport2:1: 0W 0deg
  antenna:1: 1000000W 0deg
reports:
  Forward Transmission Coefficient Antenna Waveport: dB(S(waveport1:1,antenna)) vs Freq on Setup1 : Sweep
  Phase Shifts Antenna Waveports: ang_rad(S(waveport2,antenna)), ang_rad(S(waveport1,antenna)) vs Freq on Setup1 : Sweep; markers m1 at 1GHz, m2 at 1GHz

design current_loop (HFSS, HFSS Modal Network, model units mm)
variables:
  b = 12mm  # 17
  w = 30mm/2  # 27/2
  a = 20mm  # 20
  length = 100mm  # 100
  t = 0.1mm  # 0.1
  antenna_width = 1.6mm
  current_loop_radius = 0.101mm
  antenna_wire_radius = 0.1mm
  feedpoint_height = 1.6mm
  antenna_rotation_angle = 0deg
  antenna_offset = 0mm
  pos_loop1 = 1
  pos_loop2 = 1
  pos_loop3 = 1
geometry:
  upper_cell_wall = rectangle(corner=(-length/2, -a, b), x_size=length, y_size=2*a)
  lower_cell_wall = upper_cell_wall.duplicate_around_axis(axis=X, angle=180deg, total=2)
  side_wall_1 = rectangle(corner=(-length/2, -a, -b), z_size=2*b, x_size=length)
  side_wall_2 = side_wall_1.duplicate_around_axis(axis=X, angle=180deg, total=2)
  Septum [perfect conductor] = rectangle(corner=(-length/2, -w, (-t/2) mm), x_size=length, y_size=2*w)
  Septum.thicken(t, both sides)
  waveport2 = rectangle(corner=(-length/2, -a, -b), y_size=2*a, z_size=2*b)
  waveport1 = waveport2.duplicate_around_axis(axis=Z, angle=180deg, total=2)
  TEM_Cell_Confinement [vacuum] = box(corner=(-length/2, -a, -b), size=(length, 2*a, 2*b))
  RadiatingSurface [vacuum] = region(absolute_offset: +X=0mm, -X=0mm, +Y=10mm, -Y=10mm, +Z=10mm, -Z=10mm)
  coordinate_system RelativeCS9 = origin=(-75mm, 100mm, -100mm) x=(1mm, 0mm, 0mm) y=(0mm, 1mm, 0mm)
  coordinate_system RelativeCS10 = origin=(0mm, 0mm, -60mm) x=(1mm, 0mm, 0mm) y=(0mm, 1mm, 0mm) in RelativeCS9
  coordinate_system RelativeCS11 = origin=(235mm, 130mm, 0mm) x=(1mm, 0mm, 0mm) y=(0mm, 1mm, 0mm) in RelativeCS10
  coordinate_system RelativeCS12 = origin=(-85mm, -165mm, 110.5mm) x=(1mm, 0mm, 0mm) y=(0mm, 1mm, 0mm) in RelativeCS11
  coordinate_system RelativeCS13 = origin=(-75mm, -65mm, 49.5mm) x=(1mm, 0mm, 0mm) y=(0mm, 1mm, 0mm) in RelativeCS12
  coordinate_system RelativeCS14 = origin=(235mm, 130mm, 0mm) x=(1mm, 0mm, 0mm) y=(0mm, 1mm, 0mm) in RelativeCS13
  coordinate_system RelativeCS15 = origin=(-85mm, -165mm, 110.5mm) x=(1mm, 0mm, 0mm) y=(0mm, 1mm, 0mm) in RelativeCS14
  coordinate_system RelativeCS16 = origin=(1mm, 0.14142136mm, 10.35mm) x=(1mm, 0mm, 0mm) y=(0mm, 1mm, 0mm)
  coordinate_system RelativeCS17 = origin=(-0.1mm, 0mm, 1.65mm) x=(1mm, 0mm, 0mm) y=(0mm, 1mm, 0mm) in RelativeCS16
  coordinate_system RelativeCS18 = origin=(0.1mm, 0mm, 0mm) x=(1mm, 0mm, 0mm) y=(0mm, 1mm, 0mm) in RelativeCS17
  coordinate_system RelativeCS38 = origin=(-14.8mm, 3.2mm, 0mm) x=(1mm, 0mm, 0mm) y=(0mm, 1mm, 0mm) in RelativeCS37
  coordinate_system RelativeCS39 = origin=(-58.2mm, 26.541421mm, 0.05mm) x=(1mm, 0mm, 0mm) y=(0mm, 1mm, 0mm) in RelativeCS38
  coordinate_system RelativeCS40 = origin=(61.4mm, -27.8mm, 0mm) x=(1mm, 0mm, 0mm) y=(0mm, 1mm, 0mm) in RelativeCS39
  coordinate_system RelativeCS41 = origin=(-61.4mm, 27.8mm, -0.05mm) x=(1mm, 0mm, 0mm) y=(0mm, 1mm, 0mm) in RelativeCS40
  coordinate_system RelativeCS42 = origin=(4mm, 0mm, 0mm) x=(1mm, 0mm, 0mm) y=(0mm, 1mm, 0mm) in RelativeCS41
  coordinate_system RelativeCS43 = origin=(-4mm, 0mm, 0mm) x=(1mm, 0mm, 0mm) y=(0mm, 1mm, 0mm) in RelativeCS42
  coordinate_system RelativeCS44 = origin=((-0.70000000000001+0.7) mm, -0.005mm, 0mm) x=(1mm, 0mm, 0mm) y=(0mm, 1mm, 0mm) in RelativeCS43
  Cylinder6 = cylinder(axis=Z, base_centre=(0mm, antenna_offset, 0mm), radius=0.2mm, height=0.1mm) in RelativeCS44
  upper_cell_wall.subtract(Cylinder6)
  antenna_port = circle(normal=Z, centre=(0mm, 0mm, 0mm), radius=0.2mm) in RelativeCS44
  Circle3 = circle(normal=Z, centre=(0mm, 0mm, -1.55mm), radius=0.1mm) in RelativeCS18
  antenna_port.subtract(Circle3)
  Circle4 = circle(normal=Z, centre=(0mm, 0mm, 0mm), radius=0.1mm) in RelativeCS18
  antenna_port.subtract(Circle4)
  antenna_port_cap [pec] = object_from(antenna_port.edge(1 of 1))
  antenna_port_cap.thicken(0.05mm)
  coordinate_system RelativeCS19 = origin=(1.1mm, 0mm, -1.5mm) x=(1mm, 0mm, 0mm) y=(0mm, 1mm, 0mm) in RelativeCS18
  coordinate_system RelativeCS20 = origin=(-1.1mm, 0mm, 1.55mm) x=(1mm, 0mm, 0mm) y=(0mm, 1mm, 0mm) in RelativeCS19
  coordinate_system RelativeCS21 = origin=(-50mm, 0mm, 12mm) x=(1mm, 0mm, 0mm) y=(0mm, 1mm, 0mm)
  point Point1 = (0mm, 0mm, -6mm) in RelativeCS21
  coordinate_system RelativeCS22 = origin=(50mm, 0mm, -12mm) x=(1mm, 0mm, 0mm) y=(0mm, 1mm, 0mm) in RelativeCS21
  coordinate_system RelativeCS31 = origin=(-75mm, 100mm, -100mm) x=(1mm, 0mm, 0mm) y=(0mm, 1mm, 0mm) in RelativeCS22
  coordinate_system RelativeCS32 = origin=(0mm, 0mm, -60mm) x=(1mm, 0mm, 0mm) y=(0mm, 1mm, 0mm) in RelativeCS31
  coordinate_system RelativeCS23 = origin=(235mm, 130mm, 0mm) x=(1mm, 0mm, 0mm) y=(0mm, 1mm, 0mm) in RelativeCS32
  coordinate_system RelativeCS24 = origin=(-85mm, -165mm, 110.5mm) x=(1mm, 0mm, 0mm) y=(0mm, 1mm, 0mm) in RelativeCS23
  coordinate_system RelativeCS25 = origin=(-75mm, -65mm, 49.5mm) x=(1mm, 0mm, 0mm) y=(0mm, 1mm, 0mm) in RelativeCS24
  coordinate_system RelativeCS26 = origin=(235mm, 130mm, 0mm) x=(1mm, 0mm, 0mm) y=(0mm, 1mm, 0mm) in RelativeCS25
  coordinate_system RelativeCS27 = origin=(-85mm, -165mm, 110.5mm) x=(1mm, 0mm, 0mm) y=(0mm, 1mm, 0mm) in RelativeCS26
  coordinate_system RelativeCS28 = origin=(1mm, 0.14142136mm, 10.35mm) x=(1mm, 0mm, 0mm) y=(0mm, 1mm, 0mm) in RelativeCS22
  coordinate_system RelativeCS29 = origin=(-0.1mm, 0mm, 1.65mm) x=(1mm, 0mm, 0mm) y=(0mm, 1mm, 0mm) in RelativeCS28
  coordinate_system RelativeCS30 = origin=(0.1mm, 0mm, 0mm) x=(1mm, 0mm, 0mm) y=(0mm, 1mm, 0mm) in RelativeCS29
  coordinate_system RelativeCS33 = origin=(50mm, 0mm, -0.05005mm) x=(1mm, 0mm, 0mm) y=(0mm, 1mm, 0mm) in RelativeCS22
  coordinate_system RelativeCS34 = origin=(0mm, 0mm, 0.05mm) x=(1mm, 0mm, 0mm) y=(0mm, 1mm, 0mm) in RelativeCS33
  point Point2 = (0mm, 0mm, 6mm) in RelativeCS34
  coordinate_system RelativeCS35 = origin=(-49mm, 0.14142136mm, 12.00005mm) x=(1mm, 0mm, 0mm) y=(0mm, 1mm, 0mm) in RelativeCS34
  coordinate_system RelativeCS36 = origin=(-1mm, -0.14142136mm, 0mm) x=(1mm, 0mm, 0mm) y=(0mm, 1mm, 0mm) in RelativeCS35
  coordinate_system RelativeCS37 = origin=(73mm, -29.6mm, 0mm) x=(1mm, 0mm, 0mm) y=(0mm, 1mm, 0mm) in RelativeCS36
  Antenna [perfect conductor] = cylinder(axis=Z, base_centre=(0mm, 0mm, 0mm), radius=antenna_wire_radius, height=-feedpoint_height) in RelativeCS44
  Cylinder8 = cylinder(axis=X, base_centre=(-antenna_wire_radius, 0mm, -feedpoint_height), radius=antenna_wire_radius, height=antenna_width) in RelativeCS44
  Cylinder9 = cylinder(axis=Z, base_centre=(antenna_width-antenna_wire_radius, 0mm, -feedpoint_height-antenna_wire_radius), radius=antenna_wire_radius, height=feedpoint_height+antenna_wire_radius) in RelativeCS44
  Antenna.unite(Cylinder8, Cylinder9)
  current_loop_1 = circle(normal=Z, centre=(0mm, 0mm, (-feedpoint_height+antenna_wire_radius)/9*pos_loop1), radius=current_loop_radius) in RelativeCS44
  current_loop_2 = circle(normal=X, centre=(antenna_wire_radius + (antenna_width-3*antenna_wire_radius)/9 *pos_loop2, 0mm, -feedpoint_height), radius=current_loop_radius) in RelativeCS44
  current_loop_3 = circle(normal=Z, centre=(antenna_width-antenna_wire_radius, 0mm, -feedpoint_height+antenna_wire_radius+(feedpoint_height-antenna_wire_radius)/9*pos_loop3), radius=current_loop_radius) in RelativeCS44
  [Antenna, current_loop_1, current_loop_2, current_loop_3].rotate(axis=Z, angle=antenna_rotation_angle) in RelativeCS44
  [Antenna, antenna_port, antenna_port_cap, current_loop_1, current_loop_2, current_loop_3].move(0mm, antenna_offset, 0mm) in RelativeCS44
boundaries and excitations:
  PerfE1: Perfect E Objects=[upper_cell_wall, lower_cell_wall, side_wall_1, side_wall_2]
  Open1: Radiation Objects=RadiatingSurface
  waveport1: Wave Port Objects=waveport1 WavePortType=Modal NumModes=1 Modes{Mode1{CharImp=Zpi}}
  waveport2: Wave Port Objects=waveport2 WavePortType=Modal NumModes=1 Modes{Mode1{CharImp=Zpi}}
  antenna: Wave Port Objects=antenna_port WavePortType=Modal NumModes=1 Modes{Mode1{CharImp=Zpi RenormImp=50ohm}}
setups:
  Setup1: HfssDriven Frequency=3GHz MaxDeltaS=0.002 MaximumPasses=10 MinimumPasses=1 MinimumConvergedPasses=1 PercentRefinement=30 BasisOrder=1 PortAccuracy=2 DrivenSolverType="Direct Solver"
    sweep Sweep: 1MHz to 3GHz, 401 points; Type=Interpolating SaveFields InterpTolerance=0.5 InterpMaxSolns=250 InterpUsePortImped=false PassivityErrorTolerance=0.0001
source amplitudes:
  waveport1:1, waveport2:1: 0W 0deg
  antenna:1: 1000000W 0deg
reports:
  Forward Transmission Coefficient Antenna Waveport: dB(S(waveport1:1,antenna)) vs Freq on Setup1 : Sweep
  Phase Shifts Antenna Waveports: ang_rad(S(waveport2,antenna)), ang_rad(S(waveport1,antenna)) vs Freq on Setup1 : Sweep; markers m1 at 1GHz, m2 at 1GHz

design center_fed_monopole (HFSS, HFSS Modal Network, model units mm)
variables:
  b = 12mm  # 17
  w = 30mm/2  # 27/2
  a = 20mm  # 20
  length = 100mm  # 100
  t = 0.1mm  # 0.1
  antenna_width = 1.8mm
  current_loop_radius = 0.101mm
  antenna_wire_radius = 0.1mm
  feedpoint_height = 1.6mm
  bar_height = 1.7mm
  antenna_rotation_angle = 10deg
  antenna_offset = 1mm
  pos_loop1 = 1
  pos_loop2 = 1
  pos_loop4 = 1
  pos_loop3 = 1
geometry:
  upper_cell_wall = rectangle(corner=(-length/2, -a, b), x_size=length, y_size=2*a)
  lower_cell_wall = upper_cell_wall.duplicate_around_axis(axis=X, angle=180deg, total=2)
  side_wall_1 = rectangle(corner=(-length/2, -a, -b), z_size=2*b, x_size=length)
  side_wall_2 = side_wall_1.duplicate_around_axis(axis=X, angle=180deg, total=2)
  Septum [perfect conductor] = rectangle(corner=(-length/2, -w, (-t/2) mm), x_size=length, y_size=2*w)
  Septum.thicken(t, both sides)
  waveport2 = rectangle(corner=(-length/2, -a, -b), y_size=2*a, z_size=2*b)
  waveport1 = waveport2.duplicate_around_axis(axis=Z, angle=180deg, total=2)
  TEM_Cell_Confinement [vacuum] = box(corner=(-length/2, -a, -b), size=(length, 2*a, 2*b))
  RadiatingSurface [vacuum] = region(absolute_offset: +X=0mm, -X=0mm, +Y=10mm, -Y=10mm, +Z=10mm, -Z=10mm)
  coordinate_system RelativeCS9 = origin=(-75mm, 100mm, -100mm) x=(1mm, 0mm, 0mm) y=(0mm, 1mm, 0mm)
  coordinate_system RelativeCS10 = origin=(0mm, 0mm, -60mm) x=(1mm, 0mm, 0mm) y=(0mm, 1mm, 0mm) in RelativeCS9
  coordinate_system RelativeCS11 = origin=(235mm, 130mm, 0mm) x=(1mm, 0mm, 0mm) y=(0mm, 1mm, 0mm) in RelativeCS10
  coordinate_system RelativeCS12 = origin=(-85mm, -165mm, 110.5mm) x=(1mm, 0mm, 0mm) y=(0mm, 1mm, 0mm) in RelativeCS11
  coordinate_system RelativeCS13 = origin=(-75mm, -65mm, 49.5mm) x=(1mm, 0mm, 0mm) y=(0mm, 1mm, 0mm) in RelativeCS12
  coordinate_system RelativeCS14 = origin=(235mm, 130mm, 0mm) x=(1mm, 0mm, 0mm) y=(0mm, 1mm, 0mm) in RelativeCS13
  coordinate_system RelativeCS15 = origin=(-85mm, -165mm, 110.5mm) x=(1mm, 0mm, 0mm) y=(0mm, 1mm, 0mm) in RelativeCS14
  coordinate_system RelativeCS16 = origin=(1mm, 0.14142136mm, 10.35mm) x=(1mm, 0mm, 0mm) y=(0mm, 1mm, 0mm)
  coordinate_system RelativeCS17 = origin=(-0.1mm, 0mm, 1.65mm) x=(1mm, 0mm, 0mm) y=(0mm, 1mm, 0mm) in RelativeCS16
  coordinate_system RelativeCS18 = origin=(0.1mm, 0mm, 0mm) x=(1mm, 0mm, 0mm) y=(0mm, 1mm, 0mm) in RelativeCS17
  coordinate_system RelativeCS38 = origin=(-14.8mm, 3.2mm, 0mm) x=(1mm, 0mm, 0mm) y=(0mm, 1mm, 0mm) in RelativeCS37
  coordinate_system RelativeCS39 = origin=(-58.2mm, 26.541421mm, 0.05mm) x=(1mm, 0mm, 0mm) y=(0mm, 1mm, 0mm) in RelativeCS38
  coordinate_system RelativeCS40 = origin=(61.4mm, -27.8mm, 0mm) x=(1mm, 0mm, 0mm) y=(0mm, 1mm, 0mm) in RelativeCS39
  coordinate_system RelativeCS41 = origin=(-61.4mm, 27.8mm, -0.05mm) x=(1mm, 0mm, 0mm) y=(0mm, 1mm, 0mm) in RelativeCS40
  coordinate_system RelativeCS42 = origin=(4mm, 0mm, 0mm) x=(1mm, 0mm, 0mm) y=(0mm, 1mm, 0mm) in RelativeCS41
  coordinate_system RelativeCS43 = origin=(-4mm, 0mm, 0mm) x=(1mm, 0mm, 0mm) y=(0mm, 1mm, 0mm) in RelativeCS42
  coordinate_system RelativeCS44 = origin=((-0.70000000000001+0.7) mm, -0.005mm, 0mm) x=(1mm, 0mm, 0mm) y=(0mm, 1mm, 0mm) in RelativeCS43
  Cylinder6 = cylinder(axis=Z, base_centre=(0mm, antenna_offset, 0mm), radius=0.2mm, height=0.1mm) in RelativeCS44
  upper_cell_wall.subtract(Cylinder6)
  antenna_port = circle(normal=Z, centre=(0mm, 0mm, 0mm), radius=0.2mm) in RelativeCS44
  Circle3 = circle(normal=Z, centre=(0mm, 0mm, -1.55mm), radius=0.1mm) in RelativeCS18
  antenna_port.subtract(Circle3)
  Circle4 = circle(normal=Z, centre=(0mm, 0mm, 0mm), radius=0.1mm) in RelativeCS18
  antenna_port.subtract(Circle4)
  antenna_port_cap [pec] = object_from(antenna_port.edge(1 of 1))
  antenna_port_cap.thicken(0.05mm)
  coordinate_system RelativeCS19 = origin=(1.1mm, 0mm, -1.5mm) x=(1mm, 0mm, 0mm) y=(0mm, 1mm, 0mm) in RelativeCS18
  coordinate_system RelativeCS20 = origin=(-1.1mm, 0mm, 1.55mm) x=(1mm, 0mm, 0mm) y=(0mm, 1mm, 0mm) in RelativeCS19
  coordinate_system RelativeCS21 = origin=(-50mm, 0mm, 12mm) x=(1mm, 0mm, 0mm) y=(0mm, 1mm, 0mm)
  point Point1 = (0mm, 0mm, -6mm) in RelativeCS21
  coordinate_system RelativeCS22 = origin=(50mm, 0mm, -12mm) x=(1mm, 0mm, 0mm) y=(0mm, 1mm, 0mm) in RelativeCS21
  coordinate_system RelativeCS31 = origin=(-75mm, 100mm, -100mm) x=(1mm, 0mm, 0mm) y=(0mm, 1mm, 0mm) in RelativeCS22
  coordinate_system RelativeCS32 = origin=(0mm, 0mm, -60mm) x=(1mm, 0mm, 0mm) y=(0mm, 1mm, 0mm) in RelativeCS31
  coordinate_system RelativeCS23 = origin=(235mm, 130mm, 0mm) x=(1mm, 0mm, 0mm) y=(0mm, 1mm, 0mm) in RelativeCS32
  coordinate_system RelativeCS24 = origin=(-85mm, -165mm, 110.5mm) x=(1mm, 0mm, 0mm) y=(0mm, 1mm, 0mm) in RelativeCS23
  coordinate_system RelativeCS25 = origin=(-75mm, -65mm, 49.5mm) x=(1mm, 0mm, 0mm) y=(0mm, 1mm, 0mm) in RelativeCS24
  coordinate_system RelativeCS26 = origin=(235mm, 130mm, 0mm) x=(1mm, 0mm, 0mm) y=(0mm, 1mm, 0mm) in RelativeCS25
  coordinate_system RelativeCS27 = origin=(-85mm, -165mm, 110.5mm) x=(1mm, 0mm, 0mm) y=(0mm, 1mm, 0mm) in RelativeCS26
  coordinate_system RelativeCS28 = origin=(1mm, 0.14142136mm, 10.35mm) x=(1mm, 0mm, 0mm) y=(0mm, 1mm, 0mm) in RelativeCS22
  coordinate_system RelativeCS29 = origin=(-0.1mm, 0mm, 1.65mm) x=(1mm, 0mm, 0mm) y=(0mm, 1mm, 0mm) in RelativeCS28
  coordinate_system RelativeCS30 = origin=(0.1mm, 0mm, 0mm) x=(1mm, 0mm, 0mm) y=(0mm, 1mm, 0mm) in RelativeCS29
  coordinate_system RelativeCS33 = origin=(50mm, 0mm, -0.05005mm) x=(1mm, 0mm, 0mm) y=(0mm, 1mm, 0mm) in RelativeCS22
  coordinate_system RelativeCS34 = origin=(0mm, 0mm, 0.05mm) x=(1mm, 0mm, 0mm) y=(0mm, 1mm, 0mm) in RelativeCS33
  point Point2 = (0mm, 0mm, 6mm) in RelativeCS34
  coordinate_system RelativeCS35 = origin=(-49mm, 0.14142136mm, 12.00005mm) x=(1mm, 0mm, 0mm) y=(0mm, 1mm, 0mm) in RelativeCS34
  coordinate_system RelativeCS36 = origin=(-1mm, -0.14142136mm, 0mm) x=(1mm, 0mm, 0mm) y=(0mm, 1mm, 0mm) in RelativeCS35
  coordinate_system RelativeCS37 = origin=(73mm, -29.6mm, 0mm) x=(1mm, 0mm, 0mm) y=(0mm, 1mm, 0mm) in RelativeCS36
  Antenna [perfect conductor] = cylinder(axis=Z, base_centre=(0mm, 0mm, 0mm), radius=antenna_wire_radius, height=-feedpoint_height) in RelativeCS44
  Cylinder8 = cylinder(axis=X, base_centre=(-antenna_wire_radius, 0mm, -feedpoint_height), radius=antenna_wire_radius, height=antenna_width) in RelativeCS44
  Cylinder9 = cylinder(axis=Z, base_centre=(antenna_width-antenna_wire_radius, 0mm, -feedpoint_height-antenna_wire_radius), radius=antenna_wire_radius, height=feedpoint_height+antenna_wire_radius) in RelativeCS44
  Antenna.unite(Cylinder8, Cylinder9)
  current_loop_1 = circle(normal=Z, centre=(0mm, 0mm, (-feedpoint_height+antenna_wire_radius)/9*pos_loop1), radius=current_loop_radius) in RelativeCS44
  current_loop_2 = circle(normal=X, centre=(antenna_wire_radius+(antenna_width-3*antenna_wire_radius)/9 * pos_loop2, 0mm, -feedpoint_height), radius=current_loop_radius) in RelativeCS44
  current_loop_3 = circle(normal=Z, centre=(antenna_width-antenna_wire_radius, 0mm, -feedpoint_height+antenna_wire_radius+(feedpoint_height-antenna_wire_radius)/9*pos_loop3), radius=current_loop_radius) in RelativeCS44
  Cylinder10 = cylinder(axis=Z, base_centre=(antenna_width-antenna_wire_radius, 0mm, -feedpoint_height), radius=antenna_wire_radius, height=-bar_height) in RelativeCS44
  Antenna.unite(Cylinder10)
  current_loop_4 = circle(normal=Z, centre=(antenna_width-antenna_wire_radius, 0mm, -feedpoint_height-antenna_wire_radius+-(bar_height-antenna_wire_radius)/9*pos_loop4), radius=current_loop_radius) in RelativeCS44
  [Antenna, current_loop_1..current_loop_4].rotate(axis=Z, angle=antenna_rotation_angle) in RelativeCS44
  [Antenna, antenna_port, antenna_port_cap, current_loop_1..current_loop_4].move(0mm, antenna_offset, 0mm) in RelativeCS44
boundaries and excitations:
  PerfE1: Perfect E Objects=[upper_cell_wall, lower_cell_wall, side_wall_1, side_wall_2]
  Open1: Radiation Objects=RadiatingSurface
  waveport1: Wave Port Objects=waveport1 WavePortType=Modal NumModes=1 Modes{Mode1{CharImp=Zpi}}
  waveport2: Wave Port Objects=waveport2 WavePortType=Modal NumModes=1 Modes{Mode1{CharImp=Zpi}}
  antenna: Wave Port Objects=antenna_port WavePortType=Modal NumModes=1 Modes{Mode1{CharImp=Zpi RenormImp=50ohm}}
setups:
  Setup1: HfssDriven Frequency=3GHz MaxDeltaS=0.002 MaximumPasses=10 MinimumPasses=1 MinimumConvergedPasses=1 PercentRefinement=30 BasisOrder=1 PortAccuracy=2 DrivenSolverType="Direct Solver"
    sweep Sweep: 1MHz to 3GHz, 401 points; Type=Interpolating SaveFields InterpTolerance=0.5 InterpMaxSolns=250 InterpUsePortImped=false PassivityErrorTolerance=0.0001
source amplitudes:
  waveport1:1, waveport2:1: 0W 0deg
  antenna:1: 1000000W 0deg
reports:
  Forward Transmission Coefficient Antenna Waveport: dB(S(waveport1:1,antenna)) vs Freq on Setup1 : Sweep
  Phase Shifts Antenna Waveports: ang_rad(S(waveport2,antenna)), ang_rad(S(waveport1,antenna)) vs Freq on Setup1 : Sweep; markers m1 at 1GHz, m2 at 1GHz

design serial_loop (HFSS, HFSS Modal Network, model units mm)
variables:
  b = 12mm  # 17
  w = 30mm/2  # 27/2
  a = 20mm  # 20
  length = 100mm  # 100
  t = 0.1mm  # 0.1
  antenna_width = 1mm
  current_loop_radius = 0.101mm
  antenna_wire_radius = 0.1mm
  feedpoint_height = 1mm
  antenna_rotation_angle = 0deg
  antenna_offset = 0mm
  pos_loop1 = 1
  pos_loop2 = 1
  pos_loop3 = 1
  gap_height = 0.3mm
  antenna2_height = 1mm
  antenna2_width = 2mm
  pos_loop6 = 1
geometry:
  upper_cell_wall = rectangle(corner=(-length/2, -a, b), x_size=length, y_size=2*a)
  lower_cell_wall = upper_cell_wall.duplicate_around_axis(axis=X, angle=180deg, total=2)
  side_wall_1 = rectangle(corner=(-length/2, -a, -b), z_size=2*b, x_size=length)
  side_wall_2 = side_wall_1.duplicate_around_axis(axis=X, angle=180deg, total=2)
  Septum [perfect conductor] = rectangle(corner=(-length/2, -w, (-t/2) mm), x_size=length, y_size=2*w)
  Septum.thicken(t, both sides)
  waveport2 = rectangle(corner=(-length/2, -a, -b), y_size=2*a, z_size=2*b)
  waveport1 = waveport2.duplicate_around_axis(axis=Z, angle=180deg, total=2)
  TEM_Cell_Confinement [vacuum] = box(corner=(-length/2, -a, -b), size=(length, 2*a, 2*b))
  RadiatingSurface [vacuum] = region(absolute_offset: +X=0mm, -X=0mm, +Y=10mm, -Y=10mm, +Z=10mm, -Z=10mm)
  coordinate_system RelativeCS9 = origin=(-75mm, 100mm, -100mm) x=(1mm, 0mm, 0mm) y=(0mm, 1mm, 0mm)
  coordinate_system RelativeCS10 = origin=(0mm, 0mm, -60mm) x=(1mm, 0mm, 0mm) y=(0mm, 1mm, 0mm) in RelativeCS9
  coordinate_system RelativeCS11 = origin=(235mm, 130mm, 0mm) x=(1mm, 0mm, 0mm) y=(0mm, 1mm, 0mm) in RelativeCS10
  coordinate_system RelativeCS12 = origin=(-85mm, -165mm, 110.5mm) x=(1mm, 0mm, 0mm) y=(0mm, 1mm, 0mm) in RelativeCS11
  coordinate_system RelativeCS13 = origin=(-75mm, -65mm, 49.5mm) x=(1mm, 0mm, 0mm) y=(0mm, 1mm, 0mm) in RelativeCS12
  coordinate_system RelativeCS14 = origin=(235mm, 130mm, 0mm) x=(1mm, 0mm, 0mm) y=(0mm, 1mm, 0mm) in RelativeCS13
  coordinate_system RelativeCS15 = origin=(-85mm, -165mm, 110.5mm) x=(1mm, 0mm, 0mm) y=(0mm, 1mm, 0mm) in RelativeCS14
  coordinate_system RelativeCS16 = origin=(1mm, 0.14142136mm, 10.35mm) x=(1mm, 0mm, 0mm) y=(0mm, 1mm, 0mm)
  coordinate_system RelativeCS17 = origin=(-0.1mm, 0mm, 1.65mm) x=(1mm, 0mm, 0mm) y=(0mm, 1mm, 0mm) in RelativeCS16
  coordinate_system RelativeCS18 = origin=(0.1mm, 0mm, 0mm) x=(1mm, 0mm, 0mm) y=(0mm, 1mm, 0mm) in RelativeCS17
  coordinate_system RelativeCS38 = origin=(-14.8mm, 3.2mm, 0mm) x=(1mm, 0mm, 0mm) y=(0mm, 1mm, 0mm) in RelativeCS37
  coordinate_system RelativeCS39 = origin=(-58.2mm, 26.541421mm, 0.05mm) x=(1mm, 0mm, 0mm) y=(0mm, 1mm, 0mm) in RelativeCS38
  coordinate_system RelativeCS40 = origin=(61.4mm, -27.8mm, 0mm) x=(1mm, 0mm, 0mm) y=(0mm, 1mm, 0mm) in RelativeCS39
  coordinate_system RelativeCS41 = origin=(-61.4mm, 27.8mm, -0.05mm) x=(1mm, 0mm, 0mm) y=(0mm, 1mm, 0mm) in RelativeCS40
  coordinate_system RelativeCS42 = origin=(4mm, 0mm, 0mm) x=(1mm, 0mm, 0mm) y=(0mm, 1mm, 0mm) in RelativeCS41
  coordinate_system RelativeCS43 = origin=(-4mm, 0mm, 0mm) x=(1mm, 0mm, 0mm) y=(0mm, 1mm, 0mm) in RelativeCS42
  coordinate_system RelativeCS44 = origin=((-0.70000000000001+0.7) mm, -0.005mm, 0mm) x=(1mm, 0mm, 0mm) y=(0mm, 1mm, 0mm) in RelativeCS43
  Cylinder6 = cylinder(axis=Z, base_centre=(0mm, antenna_offset, 0mm), radius=0.2mm, height=0.1mm) in RelativeCS44
  upper_cell_wall.subtract(Cylinder6)
  antenna_port = circle(normal=Z, centre=(0mm, 0mm, 0mm), radius=0.2mm) in RelativeCS44
  Circle3 = circle(normal=Z, centre=(0mm, 0mm, -1.55mm), radius=0.1mm) in RelativeCS18
  antenna_port.subtract(Circle3)
  Circle4 = circle(normal=Z, centre=(0mm, 0mm, 0mm), radius=0.1mm) in RelativeCS18
  antenna_port.subtract(Circle4)
  antenna_port_cap [pec] = object_from(antenna_port.edge(1 of 1))
  antenna_port_cap.thicken(0.05mm)
  coordinate_system RelativeCS19 = origin=(1.1mm, 0mm, -1.5mm) x=(1mm, 0mm, 0mm) y=(0mm, 1mm, 0mm) in RelativeCS18
  coordinate_system RelativeCS20 = origin=(-1.1mm, 0mm, 1.55mm) x=(1mm, 0mm, 0mm) y=(0mm, 1mm, 0mm) in RelativeCS19
  coordinate_system RelativeCS21 = origin=(-50mm, 0mm, 12mm) x=(1mm, 0mm, 0mm) y=(0mm, 1mm, 0mm)
  point Point1 = (0mm, 0mm, -6mm) in RelativeCS21
  coordinate_system RelativeCS22 = origin=(50mm, 0mm, -12mm) x=(1mm, 0mm, 0mm) y=(0mm, 1mm, 0mm) in RelativeCS21
  coordinate_system RelativeCS31 = origin=(-75mm, 100mm, -100mm) x=(1mm, 0mm, 0mm) y=(0mm, 1mm, 0mm) in RelativeCS22
  coordinate_system RelativeCS32 = origin=(0mm, 0mm, -60mm) x=(1mm, 0mm, 0mm) y=(0mm, 1mm, 0mm) in RelativeCS31
  coordinate_system RelativeCS23 = origin=(235mm, 130mm, 0mm) x=(1mm, 0mm, 0mm) y=(0mm, 1mm, 0mm) in RelativeCS32
  coordinate_system RelativeCS24 = origin=(-85mm, -165mm, 110.5mm) x=(1mm, 0mm, 0mm) y=(0mm, 1mm, 0mm) in RelativeCS23
  coordinate_system RelativeCS25 = origin=(-75mm, -65mm, 49.5mm) x=(1mm, 0mm, 0mm) y=(0mm, 1mm, 0mm) in RelativeCS24
  coordinate_system RelativeCS26 = origin=(235mm, 130mm, 0mm) x=(1mm, 0mm, 0mm) y=(0mm, 1mm, 0mm) in RelativeCS25
  coordinate_system RelativeCS27 = origin=(-85mm, -165mm, 110.5mm) x=(1mm, 0mm, 0mm) y=(0mm, 1mm, 0mm) in RelativeCS26
  coordinate_system RelativeCS28 = origin=(1mm, 0.14142136mm, 10.35mm) x=(1mm, 0mm, 0mm) y=(0mm, 1mm, 0mm) in RelativeCS22
  coordinate_system RelativeCS29 = origin=(-0.1mm, 0mm, 1.65mm) x=(1mm, 0mm, 0mm) y=(0mm, 1mm, 0mm) in RelativeCS28
  coordinate_system RelativeCS30 = origin=(0.1mm, 0mm, 0mm) x=(1mm, 0mm, 0mm) y=(0mm, 1mm, 0mm) in RelativeCS29
  coordinate_system RelativeCS33 = origin=(50mm, 0mm, -0.05005mm) x=(1mm, 0mm, 0mm) y=(0mm, 1mm, 0mm) in RelativeCS22
  coordinate_system RelativeCS34 = origin=(0mm, 0mm, 0.05mm) x=(1mm, 0mm, 0mm) y=(0mm, 1mm, 0mm) in RelativeCS33
  point Point2 = (0mm, 0mm, 6mm) in RelativeCS34
  coordinate_system RelativeCS35 = origin=(-49mm, 0.14142136mm, 12.00005mm) x=(1mm, 0mm, 0mm) y=(0mm, 1mm, 0mm) in RelativeCS34
  coordinate_system RelativeCS36 = origin=(-1mm, -0.14142136mm, 0mm) x=(1mm, 0mm, 0mm) y=(0mm, 1mm, 0mm) in RelativeCS35
  coordinate_system RelativeCS37 = origin=(73mm, -29.6mm, 0mm) x=(1mm, 0mm, 0mm) y=(0mm, 1mm, 0mm) in RelativeCS36
  Antenna [perfect conductor] = cylinder(axis=Z, base_centre=(0mm, 0mm, 0mm), radius=antenna_wire_radius, height=-feedpoint_height) in RelativeCS44
  Cylinder8 = cylinder(axis=X, base_centre=(-antenna_wire_radius, 0mm, -feedpoint_height), radius=antenna_wire_radius, height=antenna_width) in RelativeCS44
  Cylinder9 = cylinder(axis=Z, base_centre=(antenna_width-antenna_wire_radius, 0mm, -feedpoint_height-antenna_wire_radius), radius=antenna_wire_radius, height=feedpoint_height+antenna_wire_radius-gap_height) in RelativeCS44
  current_loop_1 = circle(normal=Z, centre=(0mm, 0mm, (-feedpoint_height+antenna_wire_radius)/9*pos_loop1), radius=current_loop_radius) in RelativeCS44
  current_loop_2 = circle(normal=X, centre=(antenna_wire_radius + (antenna_width-3*antenna_wire_radius)/9 *pos_loop2, 0mm, -feedpoint_height), radius=current_loop_radius) in RelativeCS44
  current_loop_3 = circle(normal=Z, centre=(antenna_width-antenna_wire_radius, 0mm, -feedpoint_height+antenna_wire_radius+(feedpoint_height-antenna_wire_radius)/9*pos_loop3), radius=current_loop_radius) in RelativeCS44
  [current_loop_1, current_loop_2, current_loop_3].rotate(axis=Z, angle=antenna_rotation_angle) in RelativeCS44
  [antenna_port, antenna_port_cap, current_loop_1, current_loop_2, current_loop_3].move(0mm, antenna_offset, 0mm) in RelativeCS44
  Cylinder10 = cylinder(axis=Z, base_centre=(antenna_width-antenna_wire_radius, 0mm, -feedpoint_height-antenna_wire_radius), radius=antenna_wire_radius, height=-antenna2_height) in RelativeCS44
  Cylinder11 = cylinder(axis=X, base_centre=(antenna_width-2*antenna_wire_radius, 0mm, -feedpoint_height-antenna2_height-antenna_wire_radius), radius=antenna_wire_radius, height=antenna2_width) in RelativeCS44
  Cylinder12 = cylinder(axis=Z, base_centre=(antenna_width+antenna2_width-antenna_wire_radius*2, 0mm, -antenna2_height-feedpoint_height-antenna_wire_radius*2), radius=0.1mm, height=antenna2_height+feedpoint_height+antenna_wire_radius*2) in RelativeCS44
  Antenna.unite(Cylinder10, Cylinder11, Cylinder12, Cylinder8, Cylinder9)
  Antenna.rotate(axis=Z, angle=antenna_rotation_angle) in RelativeCS44
  Antenna.move(0mm, antenna_offset, 0mm) in RelativeCS44
  current_loop_6 = circle(normal=Z, centre=(antenna2_width+antenna_width-antenna_wire_radius*2, 0mm, -(antenna2_height+feedpoint_height)*pos_loop6/9), radius=current_loop_radius) in RelativeCS44
  current_loop_6.rotate(axis=Z, angle=antenna_rotation_angle) in RelativeCS44
  current_loop_6.move(0mm, antenna_offset, 0mm) in RelativeCS44
boundaries and excitations:
  PerfE1: Perfect E Objects=[upper_cell_wall, lower_cell_wall, side_wall_1, side_wall_2]
  Open1: Radiation Objects=RadiatingSurface
  waveport1: Wave Port Objects=waveport1 WavePortType=Modal NumModes=1 Modes{Mode1{CharImp=Zpi}}
  waveport2: Wave Port Objects=waveport2 WavePortType=Modal NumModes=1 Modes{Mode1{CharImp=Zpi}}
  antenna: Wave Port Objects=antenna_port WavePortType=Modal NumModes=1 Modes{Mode1{CharImp=Zpi RenormImp=50ohm}}
setups:
  Setup1: HfssDriven Frequency=3GHz MaxDeltaS=0.002 MaximumPasses=10 MinimumPasses=1 MinimumConvergedPasses=1 PercentRefinement=30 BasisOrder=1 PortAccuracy=2 DrivenSolverType="Direct Solver"
    sweep Sweep: 1MHz to 3GHz, 401 points; Type=Interpolating SaveFields InterpTolerance=0.5 InterpMaxSolns=250 InterpUsePortImped=false PassivityErrorTolerance=0.0001
source amplitudes:
  waveport1:1, waveport2:1: 0W 0deg
  antenna:1: 1000000W 0deg
optimetrics:
  gap_sweep: Parametric Sim._Setups=[Setup1]
    sweep gap_height: LIN 0.01mm 0.51mm 0.05mm
field calculator expressions:
  loop3_I_real = <Hx,Hy,Hz> | Real | Tangent | Dot | EnterLine(current_loop_3) | LineValue | Integrate
  loop3_I_imag = <Hx,Hy,Hz> | Imag | Tangent | Dot | EnterLine(current_loop_3) | LineValue | Integrate
  loop6_I_real = <Hx,Hy,Hz> | Real | Tangent | Dot | EnterLine(current_loop_6) | LineValue | Integrate
  loop6_I_imag = <Hx,Hy,Hz> | Imag | Tangent | Dot | EnterLine(current_loop_6) | LineValue | Integrate
reports:
  Forward Transmission Coefficient Antenna Waveport: dB(S(waveport1:1,antenna)) vs Freq on Setup1 : Sweep
  Phase Shifts Antenna Waveports: ang_rad(S(waveport2,antenna)), ang_rad(S(waveport1,antenna)) vs Freq on Setup1 : Sweep; markers m1 at 1GHz, m2 at 1GHz
  Branch Currents 3 GHz: sqrt(loop3_I_real*loop3_I_real+loop3_I_imag*loop3_I_imag), sqrt(loop6_I_real*loop6_I_real+loop6_I_imag*loop6_I_imag) vs gap_height on Setup1 : LastAdaptive [Phase=0deg Freq=3GHz]
